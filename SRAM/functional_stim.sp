* Functional test stimulus file for 5ns period

* TT process corner
.include "/home/lib/NangateOpenCellLibrary_PDKv1_3_v2010_12/ncsu_basekit/models/hspice/tran_models/models_nom/PMOS_VTG.inc"
.include "/home/lib/NangateOpenCellLibrary_PDKv1_3_v2010_12/ncsu_basekit/models/hspice/tran_models/models_nom/NMOS_VTG.inc"
.include "sram_w8_b256_freepdk45.sp"

* Global Power Supplies
Vvdd vdd 0 1.0

*Nodes gnd and 0 are the same global ground node in ngspice/hspice/xa. Otherwise, this source may be needed.
*Vgnd gnd 0 0.0

* Instantiation of the SRAM
Xsram_w8_b256_freepdk45 din0_0 din0_1 din0_2 din0_3 din0_4 din0_5 din0_6 din0_7 a0_0 a0_1 a0_2 a0_3 a0_4 a0_5 a0_6 a0_7 CSB0 WEB0 clk0 dout0_0 dout0_1 dout0_2 dout0_3 dout0_4 dout0_5 dout0_6 dout0_7 vdd gnd sram_w8_b256_freepdk45

* SRAM output loads
CD00 dout0_0  0 0.8364f
CD01 dout0_1  0 0.8364f
CD02 dout0_2  0 0.8364f
CD03 dout0_3  0 0.8364f
CD04 dout0_4  0 0.8364f
CD05 dout0_5  0 0.8364f
CD06 dout0_6  0 0.8364f
CD07 dout0_7  0 0.8364f

* Important signals for debug
* bl:	xsram_w8_b256_freepdk45.xbank0.bl_0_0
* br:	xsram_w8_b256_freepdk45.xbank0.br_0_0
* s_en:	xsram_w8_b256_freepdk45.s_en
* q:	xsram_w8_b256_freepdk45.xbank0.xbitcell_array.xbitcell_array.xbit_r0_c0.Q
* qbar:	xsram_w8_b256_freepdk45.xbank0.xbitcell_array.xbitcell_array.xbit_r0_c0.Q_bar

* Sequence of operations
*	Idle during cycle 0 (0ns - 5ns)
*	Writing 01111101  to  address 00000111 (from port 0) during cycle 1 (5ns - 10ns)
*	Writing 10001111  to  address 00000001 (from port 0) during cycle 2 (10ns - 15ns)
*	Writing 01000000  to  address 11111010 (from port 0) during cycle 3 (15ns - 20ns)
*	Reading 01111101 from address 00000111 (from port 0) during cycle 4 (20ns - 25ns)
*	Reading 01111101 from address 00000111 (from port 0) during cycle 5 (25ns - 30ns)
*	Reading 10001111 from address 00000001 (from port 0) during cycle 7 (35ns - 40ns)
*	Reading 01000000 from address 11111010 (from port 0) during cycle 8 (40ns - 45ns)
*	Reading 01000000 from address 11111010 (from port 0) during cycle 9 (45ns - 50ns)
*	Writing 01000001  to  address 00000000 (from port 0) during cycle 11 (55ns - 60ns)
*	Writing 00101011  to  address 11110111 (from port 0) during cycle 12 (60ns - 65ns)
*	Writing 10101011  to  address 00000000 (from port 0) during cycle 14 (70ns - 75ns)
*	Writing 11011001  to  address 11111110 (from port 0) during cycle 15 (75ns - 80ns)
*	Reading 11011001 from address 11111110 (from port 0) during cycle 16 (80ns - 85ns)
*	Reading 01111101 from address 00000111 (from port 0) during cycle 17 (85ns - 90ns)
*	Writing 01100001  to  address 00000101 (from port 0) during cycle 19 (95ns - 100ns)
*	Reading 01000000 from address 11111010 (from port 0) during cycle 20 (100ns - 105ns)
*	Reading 01111101 from address 00000111 (from port 0) during cycle 21 (105ns - 110ns)
*	Reading 00101011 from address 11110111 (from port 0) during cycle 22 (110ns - 115ns)
*	Reading 01100001 from address 00000101 (from port 0) during cycle 23 (115ns - 120ns)
*	Writing 10110101  to  address 11111001 (from port 0) during cycle 24 (120ns - 125ns)
*	Reading 01000000 from address 11111010 (from port 0) during cycle 25 (125ns - 130ns)
*	Reading 10101011 from address 00000000 (from port 0) during cycle 26 (130ns - 135ns)
*	Writing 00111110  to  address 00000010 (from port 0) during cycle 27 (135ns - 140ns)
*	Writing 00000110  to  address 00000110 (from port 0) during cycle 28 (140ns - 145ns)
*	Reading 00111110 from address 00000010 (from port 0) during cycle 29 (145ns - 150ns)
*	Reading 01000000 from address 11111010 (from port 0) during cycle 30 (150ns - 155ns)
*	Reading 01000000 from address 11111010 (from port 0) during cycle 31 (155ns - 160ns)
*	Reading 10001111 from address 00000001 (from port 0) during cycle 33 (165ns - 170ns)
*	Reading 00101011 from address 11110111 (from port 0) during cycle 35 (175ns - 180ns)
*	Reading 01111101 from address 00000111 (from port 0) during cycle 37 (185ns - 190ns)
*	Reading 00101011 from address 11110111 (from port 0) during cycle 38 (190ns - 195ns)
*	Writing 01111011  to  address 11111001 (from port 0) during cycle 40 (200ns - 205ns)
*	Writing 10000101  to  address 00000101 (from port 0) during cycle 41 (205ns - 210ns)
*	Reading 01111011 from address 11111001 (from port 0) during cycle 42 (210ns - 215ns)
*	Reading 00101011 from address 11110111 (from port 0) during cycle 43 (215ns - 220ns)
*	Reading 01000000 from address 11111010 (from port 0) during cycle 44 (220ns - 225ns)
*	Reading 00000110 from address 00000110 (from port 0) during cycle 46 (230ns - 235ns)
*	Reading 00000110 from address 00000110 (from port 0) during cycle 47 (235ns - 240ns)
*	Reading 10101011 from address 00000000 (from port 0) during cycle 48 (240ns - 245ns)
*	Reading 11011001 from address 11111110 (from port 0) during cycle 49 (245ns - 250ns)
*	Writing 10101000  to  address 00000001 (from port 0) during cycle 51 (255ns - 260ns)
*	Writing 00100001  to  address 00000101 (from port 0) during cycle 52 (260ns - 265ns)
*	Reading 00100001 from address 00000101 (from port 0) during cycle 54 (270ns - 275ns)
*	Writing 11001001  to  address 00000011 (from port 0) during cycle 55 (275ns - 280ns)
*	Reading 00101011 from address 11110111 (from port 0) during cycle 56 (280ns - 285ns)
*	Writing 00000111  to  address 00000011 (from port 0) during cycle 57 (285ns - 290ns)
*	Reading 01000000 from address 11111010 (from port 0) during cycle 59 (295ns - 300ns)
*	Reading 10101011 from address 00000000 (from port 0) during cycle 60 (300ns - 305ns)
*	Reading 01111101 from address 00000111 (from port 0) during cycle 61 (305ns - 310ns)
*	Reading 00100001 from address 00000101 (from port 0) during cycle 62 (310ns - 315ns)
*	Reading 00000111 from address 00000011 (from port 0) during cycle 63 (315ns - 320ns)
*	Writing 10111010  to  address 11111000 (from port 0) during cycle 64 (320ns - 325ns)
*	Reading 10111010 from address 11111000 (from port 0) during cycle 65 (325ns - 330ns)
*	Reading 10111010 from address 11111000 (from port 0) during cycle 67 (335ns - 340ns)
*	Reading 00100001 from address 00000101 (from port 0) during cycle 68 (340ns - 345ns)
*	Writing 10001000  to  address 11111011 (from port 0) during cycle 69 (345ns - 350ns)
*	Writing 00010000  to  address 00000001 (from port 0) during cycle 70 (350ns - 355ns)
*	Reading 10001000 from address 11111011 (from port 0) during cycle 73 (365ns - 370ns)
*	Reading 00000110 from address 00000110 (from port 0) during cycle 74 (370ns - 375ns)
*	Reading 01000000 from address 11111010 (from port 0) during cycle 76 (380ns - 385ns)
*	Reading 10001000 from address 11111011 (from port 0) during cycle 77 (385ns - 390ns)
*	Reading 00101011 from address 11110111 (from port 0) during cycle 78 (390ns - 395ns)
*	Writing 00010011  to  address 11111010 (from port 0) during cycle 79 (395ns - 400ns)
*	Reading 00101011 from address 11110111 (from port 0) during cycle 81 (405ns - 410ns)
*	Writing 10001110  to  address 00000001 (from port 0) during cycle 82 (410ns - 415ns)
*	Reading 11011001 from address 11111110 (from port 0) during cycle 84 (420ns - 425ns)
*	Reading 00101011 from address 11110111 (from port 0) during cycle 85 (425ns - 430ns)
*	Reading 10001000 from address 11111011 (from port 0) during cycle 86 (430ns - 435ns)
*	Reading 00111110 from address 00000010 (from port 0) during cycle 87 (435ns - 440ns)
*	Reading 10101011 from address 00000000 (from port 0) during cycle 88 (440ns - 445ns)
*	Writing 11100000  to  address 00000100 (from port 0) during cycle 89 (445ns - 450ns)
*	Writing 10001111  to  address 00000001 (from port 0) during cycle 90 (450ns - 455ns)
*	Writing 00010000  to  address 11111100 (from port 0) during cycle 91 (455ns - 460ns)
*	Reading 00000111 from address 00000011 (from port 0) during cycle 92 (460ns - 465ns)
*	Writing 00010011  to  address 11111101 (from port 0) during cycle 94 (470ns - 475ns)
*	Writing 01010101  to  address 11111100 (from port 0) during cycle 95 (475ns - 480ns)
*	Reading 01111011 from address 11111001 (from port 0) during cycle 96 (480ns - 485ns)
*	Reading 00000111 from address 00000011 (from port 0) during cycle 97 (485ns - 490ns)
*	Reading 00000110 from address 00000110 (from port 0) during cycle 99 (495ns - 500ns)
*	Reading 00111110 from address 00000010 (from port 0) during cycle 100 (500ns - 505ns)
*	Reading 00100001 from address 00000101 (from port 0) during cycle 101 (505ns - 510ns)
*	Reading 10001000 from address 11111011 (from port 0) during cycle 103 (515ns - 520ns)
*	Writing 11111010  to  address 11111000 (from port 0) during cycle 104 (520ns - 525ns)
*	Reading 00000111 from address 00000011 (from port 0) during cycle 105 (525ns - 530ns)
*	Reading 00000111 from address 00000011 (from port 0) during cycle 106 (530ns - 535ns)
*	Reading 00101011 from address 11110111 (from port 0) during cycle 107 (535ns - 540ns)
*	Reading 01010101 from address 11111100 (from port 0) during cycle 109 (545ns - 550ns)
*	Reading 00010011 from address 11111101 (from port 0) during cycle 110 (550ns - 555ns)
*	Reading 00101011 from address 11110111 (from port 0) during cycle 112 (560ns - 565ns)
*	Reading 10101011 from address 00000000 (from port 0) during cycle 114 (570ns - 575ns)
*	Writing 11000000  to  address 00000111 (from port 0) during cycle 115 (575ns - 580ns)
*	Reading 11000000 from address 00000111 (from port 0) during cycle 116 (580ns - 585ns)
*	Reading 11111010 from address 11111000 (from port 0) during cycle 117 (585ns - 590ns)
*	Writing 10100001  to  address 11111001 (from port 0) during cycle 119 (595ns - 600ns)
*	Reading 10001000 from address 11111011 (from port 0) during cycle 121 (605ns - 610ns)
*	Reading 00100001 from address 00000101 (from port 0) during cycle 122 (610ns - 615ns)
*	Reading 00010011 from address 11111010 (from port 0) during cycle 123 (615ns - 620ns)
*	Writing 00100010  to  address 11111100 (from port 0) during cycle 125 (625ns - 630ns)
*	Writing 11110011  to  address 00000011 (from port 0) during cycle 126 (630ns - 635ns)
*	Reading 00000110 from address 00000110 (from port 0) during cycle 127 (635ns - 640ns)
*	Writing 01001000  to  address 00000001 (from port 0) during cycle 128 (640ns - 645ns)
*	Reading 11000000 from address 00000111 (from port 0) during cycle 129 (645ns - 650ns)
*	Writing 01100110  to  address 11111010 (from port 0) during cycle 131 (655ns - 660ns)
*	Reading 11000000 from address 00000111 (from port 0) during cycle 132 (660ns - 665ns)
*	Writing 01111011  to  address 00000110 (from port 0) during cycle 133 (665ns - 670ns)
*	Writing 11001100  to  address 11111011 (from port 0) during cycle 135 (675ns - 680ns)
*	Writing 10110100  to  address 00000111 (from port 0) during cycle 136 (680ns - 685ns)
*	Reading 01100110 from address 11111010 (from port 0) during cycle 137 (685ns - 690ns)
*	Writing 01111100  to  address 00000110 (from port 0) during cycle 139 (695ns - 700ns)
*	Reading 00010011 from address 11111101 (from port 0) during cycle 140 (700ns - 705ns)
*	Reading 11110011 from address 00000011 (from port 0) during cycle 142 (710ns - 715ns)
*	Writing 10001001  to  address 00000111 (from port 0) during cycle 143 (715ns - 720ns)
*	Reading 01100110 from address 11111010 (from port 0) during cycle 144 (720ns - 725ns)
*	Reading 00101011 from address 11110111 (from port 0) during cycle 145 (725ns - 730ns)
*	Reading 01100110 from address 11111010 (from port 0) during cycle 146 (730ns - 735ns)
*	Writing 01011100  to  address 11111100 (from port 0) during cycle 150 (750ns - 755ns)
*	Reading 00111110 from address 00000010 (from port 0) during cycle 152 (760ns - 765ns)
*	Reading 01011100 from address 11111100 (from port 0) during cycle 153 (765ns - 770ns)
*	Writing 10011110  to  address 11111011 (from port 0) during cycle 155 (775ns - 780ns)
*	Reading 10100001 from address 11111001 (from port 0) during cycle 156 (780ns - 785ns)
*	Reading 01100110 from address 11111010 (from port 0) during cycle 157 (785ns - 790ns)
*	Writing 11110101  to  address 00000100 (from port 0) during cycle 158 (790ns - 795ns)
*	Writing 11000000  to  address 11111110 (from port 0) during cycle 159 (795ns - 800ns)
*	Writing 01110100  to  address 11111001 (from port 0) during cycle 160 (800ns - 805ns)
*	Reading 00100001 from address 00000101 (from port 0) during cycle 161 (805ns - 810ns)
*	Reading 00100001 from address 00000101 (from port 0) during cycle 162 (810ns - 815ns)
*	Reading 11110101 from address 00000100 (from port 0) during cycle 163 (815ns - 820ns)
*	Writing 00001110  to  address 00000100 (from port 0) during cycle 164 (820ns - 825ns)
*	Reading 01111100 from address 00000110 (from port 0) during cycle 167 (835ns - 840ns)
*	Reading 11000000 from address 11111110 (from port 0) during cycle 168 (840ns - 845ns)
*	Reading 01001000 from address 00000001 (from port 0) during cycle 169 (845ns - 850ns)
*	Writing 00011011  to  address 11111010 (from port 0) during cycle 171 (855ns - 860ns)
*	Reading 11111010 from address 11111000 (from port 0) during cycle 172 (860ns - 865ns)
*	Reading 01110100 from address 11111001 (from port 0) during cycle 173 (865ns - 870ns)
*	Reading 01110100 from address 11111001 (from port 0) during cycle 174 (870ns - 875ns)
*	Reading 01011100 from address 11111100 (from port 0) during cycle 175 (875ns - 880ns)
*	Reading 01110100 from address 11111001 (from port 0) during cycle 176 (880ns - 885ns)
*	Writing 00111100  to  address 11111101 (from port 0) during cycle 179 (895ns - 900ns)
*	Reading 00111100 from address 11111101 (from port 0) during cycle 180 (900ns - 905ns)
*	Writing 10011100  to  address 11111000 (from port 0) during cycle 181 (905ns - 910ns)
*	Reading 10011110 from address 11111011 (from port 0) during cycle 182 (910ns - 915ns)
*	Writing 10101111  to  address 11111011 (from port 0) during cycle 183 (915ns - 920ns)
*	Writing 11001101  to  address 11110111 (from port 0) during cycle 184 (920ns - 925ns)
*	Reading 10001001 from address 00000111 (from port 0) during cycle 185 (925ns - 930ns)
*	Writing 01011100  to  address 11110111 (from port 0) during cycle 186 (930ns - 935ns)
*	Reading 10101111 from address 11111011 (from port 0) during cycle 187 (935ns - 940ns)
*	Reading 11110011 from address 00000011 (from port 0) during cycle 189 (945ns - 950ns)
*	Reading 00100001 from address 00000101 (from port 0) during cycle 191 (955ns - 960ns)
*	Writing 01101011  to  address 00000110 (from port 0) during cycle 192 (960ns - 965ns)
*	Writing 01101101  to  address 11111000 (from port 0) during cycle 193 (965ns - 970ns)
*	Reading 10001001 from address 00000111 (from port 0) during cycle 194 (970ns - 975ns)
*	Reading 01110100 from address 11111001 (from port 0) during cycle 195 (975ns - 980ns)
*	Reading 01011100 from address 11110111 (from port 0) during cycle 196 (980ns - 985ns)
*	Reading 01011100 from address 11110111 (from port 0) during cycle 197 (985ns - 990ns)
*	Reading 11110011 from address 00000011 (from port 0) during cycle 199 (995ns - 1000ns)
*	Reading 10101111 from address 11111011 (from port 0) during cycle 201 (1005ns - 1010ns)
*	Writing 11000011  to  address 11110111 (from port 0) during cycle 203 (1015ns - 1020ns)
*	Idle during cycle 205 (1025ns - 1030ns)

* Generation of data and address signals
* (time, data): [(0, 0), (5, 1), (10, 1), (15, 0), (20, 0), (25, 0), (30, 0), (35, 0), (40, 0), (45, 0), (50, 0), (55, 1), (60, 1), (65, 1), (70, 1), (75, 1), (80, 1), (85, 1), (90, 1), (95, 1), (100, 1), (105, 1), (110, 1), (115, 1), (120, 1), (125, 1), (130, 1), (135, 0), (140, 0), (145, 0), (150, 0), (155, 0), (160, 0), (165, 0), (170, 0), (175, 0), (180, 0), (185, 0), (190, 0), (195, 0), (200, 1), (205, 1), (210, 1), (215, 1), (220, 1), (225, 1), (230, 1), (235, 1), (240, 1), (245, 1), (250, 1), (255, 0), (260, 1), (265, 1), (270, 1), (275, 1), (280, 1), (285, 1), (290, 1), (295, 1), (300, 1), (305, 1), (310, 1), (315, 1), (320, 0), (325, 0), (330, 0), (335, 0), (340, 0), (345, 0), (350, 0), (355, 0), (360, 0), (365, 0), (370, 0), (375, 0), (380, 0), (385, 0), (390, 0), (395, 1), (400, 1), (405, 1), (410, 0), (415, 0), (420, 0), (425, 0), (430, 0), (435, 0), (440, 0), (445, 0), (450, 1), (455, 0), (460, 0), (465, 0), (470, 1), (475, 1), (480, 1), (485, 1), (490, 1), (495, 1), (500, 1), (505, 1), (510, 1), (515, 1), (520, 0), (525, 0), (530, 0), (535, 0), (540, 0), (545, 0), (550, 0), (555, 0), (560, 0), (565, 0), (570, 0), (575, 0), (580, 0), (585, 0), (590, 0), (595, 1), (600, 1), (605, 1), (610, 1), (615, 1), (620, 1), (625, 0), (630, 1), (635, 1), (640, 0), (645, 0), (650, 0), (655, 0), (660, 0), (665, 1), (670, 1), (675, 0), (680, 0), (685, 0), (690, 0), (695, 0), (700, 0), (705, 0), (710, 0), (715, 1), (720, 1), (725, 1), (730, 1), (735, 1), (740, 1), (745, 1), (750, 0), (755, 0), (760, 0), (765, 0), (770, 0), (775, 0), (780, 0), (785, 0), (790, 1), (795, 0), (800, 0), (805, 0), (810, 0), (815, 0), (820, 0), (825, 0), (830, 0), (835, 0), (840, 0), (845, 0), (850, 0), (855, 1), (860, 1), (865, 1), (870, 1), (875, 1), (880, 1), (885, 1), (890, 1), (895, 0), (900, 0), (905, 0), (910, 0), (915, 1), (920, 1), (925, 1), (930, 0), (935, 0), (940, 0), (945, 0), (950, 0), (955, 0), (960, 1), (965, 1), (970, 1), (975, 1), (980, 1), (985, 1), (990, 1), (995, 1), (1000, 1), (1005, 1), (1010, 1), (1015, 1), (1020, 1), (1025, 1)]
Vdin0_0  din0_0  0 PWL (0n 0.0v 4.745n 0.0v 4.755n 1.0v 9.745n 1.0v 9.755n 1.0v 14.745n 1.0v 14.755n 0.0v 19.745n 0.0v 19.755n 0.0v 24.745n 0.0v 24.755n 0.0v 29.745n 0.0v 29.755n 0.0v 34.745n 0.0v 34.755n 0.0v 39.745n 0.0v 39.755n 0.0v 44.745n 0.0v 44.755n 0.0v 49.745n 0.0v 49.755n 0.0v 54.745n 0.0v 54.755n 1.0v 59.745n 1.0v 59.755n 1.0v 64.745n 1.0v 64.755n 1.0v 69.745n 1.0v 69.755n 1.0v 74.745n 1.0v 74.755n 1.0v 79.745n 1.0v 79.755n 1.0v 84.745n 1.0v 84.755n 1.0v 89.745n 1.0v 89.755n 1.0v 94.745n 1.0v 94.755n 1.0v 99.745n 1.0v 99.755n 1.0v 104.745n 1.0v 104.755n 1.0v 109.745n 1.0v 109.755n 1.0v 114.745n 1.0v 114.755n 1.0v 119.745n 1.0v 119.755n 1.0v 124.745n 1.0v 124.755n 1.0v 129.745n 1.0v 129.755n 1.0v 134.745n 1.0v 134.755n 0.0v 139.745n 0.0v 139.755n 0.0v 144.745n 0.0v 144.755n 0.0v 149.745n 0.0v 149.755n 0.0v 154.745n 0.0v 154.755n 0.0v 159.745n 0.0v 159.755n 0.0v 164.745n 0.0v 164.755n 0.0v 169.745n 0.0v 169.755n 0.0v 174.745n 0.0v 174.755n 0.0v 179.745n 0.0v 179.755n 0.0v 184.745n 0.0v 184.755n 0.0v 189.745n 0.0v 189.755n 0.0v 194.745n 0.0v 194.755n 0.0v 199.745n 0.0v 199.755n 1.0v 204.745n 1.0v 204.755n 1.0v 209.745n 1.0v 209.755n 1.0v 214.745n 1.0v 214.755n 1.0v 219.745n 1.0v 219.755n 1.0v 224.745n 1.0v 224.755n 1.0v 229.745n 1.0v 229.755n 1.0v 234.745n 1.0v 234.755n 1.0v 239.745n 1.0v 239.755n 1.0v 244.745n 1.0v 244.755n 1.0v 249.745n 1.0v 249.755n 1.0v 254.745n 1.0v 254.755n 0.0v 259.745n 0.0v 259.755n 1.0v 264.745n 1.0v 264.755n 1.0v 269.745n 1.0v 269.755n 1.0v 274.745n 1.0v 274.755n 1.0v 279.745n 1.0v 279.755n 1.0v 284.745n 1.0v 284.755n 1.0v 289.745n 1.0v 289.755n 1.0v 294.745n 1.0v 294.755n 1.0v 299.745n 1.0v 299.755n 1.0v 304.745n 1.0v 304.755n 1.0v 309.745n 1.0v 309.755n 1.0v 314.745n 1.0v 314.755n 1.0v 319.745n 1.0v 319.755n 0.0v 324.745n 0.0v 324.755n 0.0v 329.745n 0.0v 329.755n 0.0v 334.745n 0.0v 334.755n 0.0v 339.745n 0.0v 339.755n 0.0v 344.745n 0.0v 344.755n 0.0v 349.745n 0.0v 349.755n 0.0v 354.745n 0.0v 354.755n 0.0v 359.745n 0.0v 359.755n 0.0v 364.745n 0.0v 364.755n 0.0v 369.745n 0.0v 369.755n 0.0v 374.745n 0.0v 374.755n 0.0v 379.745n 0.0v 379.755n 0.0v 384.745n 0.0v 384.755n 0.0v 389.745n 0.0v 389.755n 0.0v 394.745n 0.0v 394.755n 1.0v 399.745n 1.0v 399.755n 1.0v 404.745n 1.0v 404.755n 1.0v 409.745n 1.0v 409.755n 0.0v 414.745n 0.0v 414.755n 0.0v 419.745n 0.0v 419.755n 0.0v 424.745n 0.0v 424.755n 0.0v 429.745n 0.0v 429.755n 0.0v 434.745n 0.0v 434.755n 0.0v 439.745n 0.0v 439.755n 0.0v 444.745n 0.0v 444.755n 0.0v 449.745n 0.0v 449.755n 1.0v 454.745n 1.0v 454.755n 0.0v 459.745n 0.0v 459.755n 0.0v 464.745n 0.0v 464.755n 0.0v 469.745n 0.0v 469.755n 1.0v 474.745n 1.0v 474.755n 1.0v 479.745n 1.0v 479.755n 1.0v 484.745n 1.0v 484.755n 1.0v 489.745n 1.0v 489.755n 1.0v 494.745n 1.0v 494.755n 1.0v 499.745n 1.0v 499.755n 1.0v 504.745n 1.0v 504.755n 1.0v 509.745n 1.0v 509.755n 1.0v 514.745n 1.0v 514.755n 1.0v 519.745n 1.0v 519.755n 0.0v 524.745n 0.0v 524.755n 0.0v 529.745n 0.0v 529.755n 0.0v 534.745n 0.0v 534.755n 0.0v 539.745n 0.0v 539.755n 0.0v 544.745n 0.0v 544.755n 0.0v 549.745n 0.0v 549.755n 0.0v 554.745n 0.0v 554.755n 0.0v 559.745n 0.0v 559.755n 0.0v 564.745n 0.0v 564.755n 0.0v 569.745n 0.0v 569.755n 0.0v 574.745n 0.0v 574.755n 0.0v 579.745n 0.0v 579.755n 0.0v 584.745n 0.0v 584.755n 0.0v 589.745n 0.0v 589.755n 0.0v 594.745n 0.0v 594.755n 1.0v 599.745n 1.0v 599.755n 1.0v 604.745n 1.0v 604.755n 1.0v 609.745n 1.0v 609.755n 1.0v 614.745n 1.0v 614.755n 1.0v 619.745n 1.0v 619.755n 1.0v 624.745n 1.0v 624.755n 0.0v 629.745n 0.0v 629.755n 1.0v 634.745n 1.0v 634.755n 1.0v 639.745n 1.0v 639.755n 0.0v 644.745n 0.0v 644.755n 0.0v 649.745n 0.0v 649.755n 0.0v 654.745n 0.0v 654.755n 0.0v 659.745n 0.0v 659.755n 0.0v 664.745n 0.0v 664.755n 1.0v 669.745n 1.0v 669.755n 1.0v 674.745n 1.0v 674.755n 0.0v 679.745n 0.0v 679.755n 0.0v 684.745n 0.0v 684.755n 0.0v 689.745n 0.0v 689.755n 0.0v 694.745n 0.0v 694.755n 0.0v 699.745n 0.0v 699.755n 0.0v 704.745n 0.0v 704.755n 0.0v 709.745n 0.0v 709.755n 0.0v 714.745n 0.0v 714.755n 1.0v 719.745n 1.0v 719.755n 1.0v 724.745n 1.0v 724.755n 1.0v 729.745n 1.0v 729.755n 1.0v 734.745n 1.0v 734.755n 1.0v 739.745n 1.0v 739.755n 1.0v 744.745n 1.0v 744.755n 1.0v 749.745n 1.0v 749.755n 0.0v 754.745n 0.0v 754.755n 0.0v 759.745n 0.0v 759.755n 0.0v 764.745n 0.0v 764.755n 0.0v 769.745n 0.0v 769.755n 0.0v 774.745n 0.0v 774.755n 0.0v 779.745n 0.0v 779.755n 0.0v 784.745n 0.0v 784.755n 0.0v 789.745n 0.0v 789.755n 1.0v 794.745n 1.0v 794.755n 0.0v 799.745n 0.0v 799.755n 0.0v 804.745n 0.0v 804.755n 0.0v 809.745n 0.0v 809.755n 0.0v 814.745n 0.0v 814.755n 0.0v 819.745n 0.0v 819.755n 0.0v 824.745n 0.0v 824.755n 0.0v 829.745n 0.0v 829.755n 0.0v 834.745n 0.0v 834.755n 0.0v 839.745n 0.0v 839.755n 0.0v 844.745n 0.0v 844.755n 0.0v 849.745n 0.0v 849.755n 0.0v 854.745n 0.0v 854.755n 1.0v 859.745n 1.0v 859.755n 1.0v 864.745n 1.0v 864.755n 1.0v 869.745n 1.0v 869.755n 1.0v 874.745n 1.0v 874.755n 1.0v 879.745n 1.0v 879.755n 1.0v 884.745n 1.0v 884.755n 1.0v 889.745n 1.0v 889.755n 1.0v 894.745n 1.0v 894.755n 0.0v 899.745n 0.0v 899.755n 0.0v 904.745n 0.0v 904.755n 0.0v 909.745n 0.0v 909.755n 0.0v 914.745n 0.0v 914.755n 1.0v 919.745n 1.0v 919.755n 1.0v 924.745n 1.0v 924.755n 1.0v 929.745n 1.0v 929.755n 0.0v 934.745n 0.0v 934.755n 0.0v 939.745n 0.0v 939.755n 0.0v 944.745n 0.0v 944.755n 0.0v 949.745n 0.0v 949.755n 0.0v 954.745n 0.0v 954.755n 0.0v 959.745n 0.0v 959.755n 1.0v 964.745n 1.0v 964.755n 1.0v 969.745n 1.0v 969.755n 1.0v 974.745n 1.0v 974.755n 1.0v 979.745n 1.0v 979.755n 1.0v 984.745n 1.0v 984.755n 1.0v 989.745n 1.0v 989.755n 1.0v 994.745n 1.0v 994.755n 1.0v 999.745n 1.0v 999.755n 1.0v 1004.745n 1.0v 1004.755n 1.0v 1009.745n 1.0v 1009.755n 1.0v 1014.745n 1.0v 1014.755n 1.0v 1019.745n 1.0v 1019.755n 1.0v 1024.745n 1.0v 1024.755n 1.0v )
* (time, data): [(0, 0), (5, 0), (10, 1), (15, 0), (20, 0), (25, 0), (30, 0), (35, 0), (40, 0), (45, 0), (50, 0), (55, 0), (60, 1), (65, 1), (70, 1), (75, 0), (80, 0), (85, 0), (90, 0), (95, 0), (100, 0), (105, 0), (110, 0), (115, 0), (120, 0), (125, 0), (130, 0), (135, 1), (140, 1), (145, 1), (150, 1), (155, 1), (160, 1), (165, 1), (170, 1), (175, 1), (180, 1), (185, 1), (190, 1), (195, 1), (200, 1), (205, 0), (210, 0), (215, 0), (220, 0), (225, 0), (230, 0), (235, 0), (240, 0), (245, 0), (250, 0), (255, 0), (260, 0), (265, 0), (270, 0), (275, 0), (280, 0), (285, 1), (290, 1), (295, 1), (300, 1), (305, 1), (310, 1), (315, 1), (320, 1), (325, 1), (330, 1), (335, 1), (340, 1), (345, 0), (350, 0), (355, 0), (360, 0), (365, 0), (370, 0), (375, 0), (380, 0), (385, 0), (390, 0), (395, 1), (400, 1), (405, 1), (410, 1), (415, 1), (420, 1), (425, 1), (430, 1), (435, 1), (440, 1), (445, 0), (450, 1), (455, 0), (460, 0), (465, 0), (470, 1), (475, 0), (480, 0), (485, 0), (490, 0), (495, 0), (500, 0), (505, 0), (510, 0), (515, 0), (520, 1), (525, 1), (530, 1), (535, 1), (540, 1), (545, 1), (550, 1), (555, 1), (560, 1), (565, 1), (570, 1), (575, 0), (580, 0), (585, 0), (590, 0), (595, 0), (600, 0), (605, 0), (610, 0), (615, 0), (620, 0), (625, 1), (630, 1), (635, 1), (640, 0), (645, 0), (650, 0), (655, 1), (660, 1), (665, 1), (670, 1), (675, 0), (680, 0), (685, 0), (690, 0), (695, 0), (700, 0), (705, 0), (710, 0), (715, 0), (720, 0), (725, 0), (730, 0), (735, 0), (740, 0), (745, 0), (750, 0), (755, 0), (760, 0), (765, 0), (770, 0), (775, 1), (780, 1), (785, 1), (790, 0), (795, 0), (800, 0), (805, 0), (810, 0), (815, 0), (820, 1), (825, 1), (830, 1), (835, 1), (840, 1), (845, 1), (850, 1), (855, 1), (860, 1), (865, 1), (870, 1), (875, 1), (880, 1), (885, 1), (890, 1), (895, 0), (900, 0), (905, 0), (910, 0), (915, 1), (920, 0), (925, 0), (930, 0), (935, 0), (940, 0), (945, 0), (950, 0), (955, 0), (960, 1), (965, 0), (970, 0), (975, 0), (980, 0), (985, 0), (990, 0), (995, 0), (1000, 0), (1005, 0), (1010, 0), (1015, 1), (1020, 1), (1025, 1)]
Vdin0_1  din0_1  0 PWL (0n 0.0v 4.745n 0.0v 4.755n 0.0v 9.745n 0.0v 9.755n 1.0v 14.745n 1.0v 14.755n 0.0v 19.745n 0.0v 19.755n 0.0v 24.745n 0.0v 24.755n 0.0v 29.745n 0.0v 29.755n 0.0v 34.745n 0.0v 34.755n 0.0v 39.745n 0.0v 39.755n 0.0v 44.745n 0.0v 44.755n 0.0v 49.745n 0.0v 49.755n 0.0v 54.745n 0.0v 54.755n 0.0v 59.745n 0.0v 59.755n 1.0v 64.745n 1.0v 64.755n 1.0v 69.745n 1.0v 69.755n 1.0v 74.745n 1.0v 74.755n 0.0v 79.745n 0.0v 79.755n 0.0v 84.745n 0.0v 84.755n 0.0v 89.745n 0.0v 89.755n 0.0v 94.745n 0.0v 94.755n 0.0v 99.745n 0.0v 99.755n 0.0v 104.745n 0.0v 104.755n 0.0v 109.745n 0.0v 109.755n 0.0v 114.745n 0.0v 114.755n 0.0v 119.745n 0.0v 119.755n 0.0v 124.745n 0.0v 124.755n 0.0v 129.745n 0.0v 129.755n 0.0v 134.745n 0.0v 134.755n 1.0v 139.745n 1.0v 139.755n 1.0v 144.745n 1.0v 144.755n 1.0v 149.745n 1.0v 149.755n 1.0v 154.745n 1.0v 154.755n 1.0v 159.745n 1.0v 159.755n 1.0v 164.745n 1.0v 164.755n 1.0v 169.745n 1.0v 169.755n 1.0v 174.745n 1.0v 174.755n 1.0v 179.745n 1.0v 179.755n 1.0v 184.745n 1.0v 184.755n 1.0v 189.745n 1.0v 189.755n 1.0v 194.745n 1.0v 194.755n 1.0v 199.745n 1.0v 199.755n 1.0v 204.745n 1.0v 204.755n 0.0v 209.745n 0.0v 209.755n 0.0v 214.745n 0.0v 214.755n 0.0v 219.745n 0.0v 219.755n 0.0v 224.745n 0.0v 224.755n 0.0v 229.745n 0.0v 229.755n 0.0v 234.745n 0.0v 234.755n 0.0v 239.745n 0.0v 239.755n 0.0v 244.745n 0.0v 244.755n 0.0v 249.745n 0.0v 249.755n 0.0v 254.745n 0.0v 254.755n 0.0v 259.745n 0.0v 259.755n 0.0v 264.745n 0.0v 264.755n 0.0v 269.745n 0.0v 269.755n 0.0v 274.745n 0.0v 274.755n 0.0v 279.745n 0.0v 279.755n 0.0v 284.745n 0.0v 284.755n 1.0v 289.745n 1.0v 289.755n 1.0v 294.745n 1.0v 294.755n 1.0v 299.745n 1.0v 299.755n 1.0v 304.745n 1.0v 304.755n 1.0v 309.745n 1.0v 309.755n 1.0v 314.745n 1.0v 314.755n 1.0v 319.745n 1.0v 319.755n 1.0v 324.745n 1.0v 324.755n 1.0v 329.745n 1.0v 329.755n 1.0v 334.745n 1.0v 334.755n 1.0v 339.745n 1.0v 339.755n 1.0v 344.745n 1.0v 344.755n 0.0v 349.745n 0.0v 349.755n 0.0v 354.745n 0.0v 354.755n 0.0v 359.745n 0.0v 359.755n 0.0v 364.745n 0.0v 364.755n 0.0v 369.745n 0.0v 369.755n 0.0v 374.745n 0.0v 374.755n 0.0v 379.745n 0.0v 379.755n 0.0v 384.745n 0.0v 384.755n 0.0v 389.745n 0.0v 389.755n 0.0v 394.745n 0.0v 394.755n 1.0v 399.745n 1.0v 399.755n 1.0v 404.745n 1.0v 404.755n 1.0v 409.745n 1.0v 409.755n 1.0v 414.745n 1.0v 414.755n 1.0v 419.745n 1.0v 419.755n 1.0v 424.745n 1.0v 424.755n 1.0v 429.745n 1.0v 429.755n 1.0v 434.745n 1.0v 434.755n 1.0v 439.745n 1.0v 439.755n 1.0v 444.745n 1.0v 444.755n 0.0v 449.745n 0.0v 449.755n 1.0v 454.745n 1.0v 454.755n 0.0v 459.745n 0.0v 459.755n 0.0v 464.745n 0.0v 464.755n 0.0v 469.745n 0.0v 469.755n 1.0v 474.745n 1.0v 474.755n 0.0v 479.745n 0.0v 479.755n 0.0v 484.745n 0.0v 484.755n 0.0v 489.745n 0.0v 489.755n 0.0v 494.745n 0.0v 494.755n 0.0v 499.745n 0.0v 499.755n 0.0v 504.745n 0.0v 504.755n 0.0v 509.745n 0.0v 509.755n 0.0v 514.745n 0.0v 514.755n 0.0v 519.745n 0.0v 519.755n 1.0v 524.745n 1.0v 524.755n 1.0v 529.745n 1.0v 529.755n 1.0v 534.745n 1.0v 534.755n 1.0v 539.745n 1.0v 539.755n 1.0v 544.745n 1.0v 544.755n 1.0v 549.745n 1.0v 549.755n 1.0v 554.745n 1.0v 554.755n 1.0v 559.745n 1.0v 559.755n 1.0v 564.745n 1.0v 564.755n 1.0v 569.745n 1.0v 569.755n 1.0v 574.745n 1.0v 574.755n 0.0v 579.745n 0.0v 579.755n 0.0v 584.745n 0.0v 584.755n 0.0v 589.745n 0.0v 589.755n 0.0v 594.745n 0.0v 594.755n 0.0v 599.745n 0.0v 599.755n 0.0v 604.745n 0.0v 604.755n 0.0v 609.745n 0.0v 609.755n 0.0v 614.745n 0.0v 614.755n 0.0v 619.745n 0.0v 619.755n 0.0v 624.745n 0.0v 624.755n 1.0v 629.745n 1.0v 629.755n 1.0v 634.745n 1.0v 634.755n 1.0v 639.745n 1.0v 639.755n 0.0v 644.745n 0.0v 644.755n 0.0v 649.745n 0.0v 649.755n 0.0v 654.745n 0.0v 654.755n 1.0v 659.745n 1.0v 659.755n 1.0v 664.745n 1.0v 664.755n 1.0v 669.745n 1.0v 669.755n 1.0v 674.745n 1.0v 674.755n 0.0v 679.745n 0.0v 679.755n 0.0v 684.745n 0.0v 684.755n 0.0v 689.745n 0.0v 689.755n 0.0v 694.745n 0.0v 694.755n 0.0v 699.745n 0.0v 699.755n 0.0v 704.745n 0.0v 704.755n 0.0v 709.745n 0.0v 709.755n 0.0v 714.745n 0.0v 714.755n 0.0v 719.745n 0.0v 719.755n 0.0v 724.745n 0.0v 724.755n 0.0v 729.745n 0.0v 729.755n 0.0v 734.745n 0.0v 734.755n 0.0v 739.745n 0.0v 739.755n 0.0v 744.745n 0.0v 744.755n 0.0v 749.745n 0.0v 749.755n 0.0v 754.745n 0.0v 754.755n 0.0v 759.745n 0.0v 759.755n 0.0v 764.745n 0.0v 764.755n 0.0v 769.745n 0.0v 769.755n 0.0v 774.745n 0.0v 774.755n 1.0v 779.745n 1.0v 779.755n 1.0v 784.745n 1.0v 784.755n 1.0v 789.745n 1.0v 789.755n 0.0v 794.745n 0.0v 794.755n 0.0v 799.745n 0.0v 799.755n 0.0v 804.745n 0.0v 804.755n 0.0v 809.745n 0.0v 809.755n 0.0v 814.745n 0.0v 814.755n 0.0v 819.745n 0.0v 819.755n 1.0v 824.745n 1.0v 824.755n 1.0v 829.745n 1.0v 829.755n 1.0v 834.745n 1.0v 834.755n 1.0v 839.745n 1.0v 839.755n 1.0v 844.745n 1.0v 844.755n 1.0v 849.745n 1.0v 849.755n 1.0v 854.745n 1.0v 854.755n 1.0v 859.745n 1.0v 859.755n 1.0v 864.745n 1.0v 864.755n 1.0v 869.745n 1.0v 869.755n 1.0v 874.745n 1.0v 874.755n 1.0v 879.745n 1.0v 879.755n 1.0v 884.745n 1.0v 884.755n 1.0v 889.745n 1.0v 889.755n 1.0v 894.745n 1.0v 894.755n 0.0v 899.745n 0.0v 899.755n 0.0v 904.745n 0.0v 904.755n 0.0v 909.745n 0.0v 909.755n 0.0v 914.745n 0.0v 914.755n 1.0v 919.745n 1.0v 919.755n 0.0v 924.745n 0.0v 924.755n 0.0v 929.745n 0.0v 929.755n 0.0v 934.745n 0.0v 934.755n 0.0v 939.745n 0.0v 939.755n 0.0v 944.745n 0.0v 944.755n 0.0v 949.745n 0.0v 949.755n 0.0v 954.745n 0.0v 954.755n 0.0v 959.745n 0.0v 959.755n 1.0v 964.745n 1.0v 964.755n 0.0v 969.745n 0.0v 969.755n 0.0v 974.745n 0.0v 974.755n 0.0v 979.745n 0.0v 979.755n 0.0v 984.745n 0.0v 984.755n 0.0v 989.745n 0.0v 989.755n 0.0v 994.745n 0.0v 994.755n 0.0v 999.745n 0.0v 999.755n 0.0v 1004.745n 0.0v 1004.755n 0.0v 1009.745n 0.0v 1009.755n 0.0v 1014.745n 0.0v 1014.755n 1.0v 1019.745n 1.0v 1019.755n 1.0v 1024.745n 1.0v 1024.755n 1.0v )
* (time, data): [(0, 0), (5, 1), (10, 1), (15, 0), (20, 0), (25, 0), (30, 0), (35, 0), (40, 0), (45, 0), (50, 0), (55, 0), (60, 0), (65, 0), (70, 0), (75, 0), (80, 0), (85, 0), (90, 0), (95, 0), (100, 0), (105, 0), (110, 0), (115, 0), (120, 1), (125, 1), (130, 1), (135, 1), (140, 1), (145, 1), (150, 1), (155, 1), (160, 1), (165, 1), (170, 1), (175, 1), (180, 1), (185, 1), (190, 1), (195, 1), (200, 0), (205, 1), (210, 1), (215, 1), (220, 1), (225, 1), (230, 1), (235, 1), (240, 1), (245, 1), (250, 1), (255, 0), (260, 0), (265, 0), (270, 0), (275, 0), (280, 0), (285, 1), (290, 1), (295, 1), (300, 1), (305, 1), (310, 1), (315, 1), (320, 0), (325, 0), (330, 0), (335, 0), (340, 0), (345, 0), (350, 0), (355, 0), (360, 0), (365, 0), (370, 0), (375, 0), (380, 0), (385, 0), (390, 0), (395, 0), (400, 0), (405, 0), (410, 1), (415, 1), (420, 1), (425, 1), (430, 1), (435, 1), (440, 1), (445, 0), (450, 1), (455, 0), (460, 0), (465, 0), (470, 0), (475, 1), (480, 1), (485, 1), (490, 1), (495, 1), (500, 1), (505, 1), (510, 1), (515, 1), (520, 0), (525, 0), (530, 0), (535, 0), (540, 0), (545, 0), (550, 0), (555, 0), (560, 0), (565, 0), (570, 0), (575, 0), (580, 0), (585, 0), (590, 0), (595, 0), (600, 0), (605, 0), (610, 0), (615, 0), (620, 0), (625, 0), (630, 0), (635, 0), (640, 0), (645, 0), (650, 0), (655, 1), (660, 1), (665, 0), (670, 0), (675, 1), (680, 1), (685, 1), (690, 1), (695, 1), (700, 1), (705, 1), (710, 1), (715, 0), (720, 0), (725, 0), (730, 0), (735, 0), (740, 0), (745, 0), (750, 1), (755, 1), (760, 1), (765, 1), (770, 1), (775, 1), (780, 1), (785, 1), (790, 1), (795, 0), (800, 1), (805, 1), (810, 1), (815, 1), (820, 1), (825, 1), (830, 1), (835, 1), (840, 1), (845, 1), (850, 1), (855, 0), (860, 0), (865, 0), (870, 0), (875, 0), (880, 0), (885, 0), (890, 0), (895, 1), (900, 1), (905, 1), (910, 1), (915, 1), (920, 1), (925, 1), (930, 1), (935, 1), (940, 1), (945, 1), (950, 1), (955, 1), (960, 0), (965, 1), (970, 1), (975, 1), (980, 1), (985, 1), (990, 1), (995, 1), (1000, 1), (1005, 1), (1010, 1), (1015, 0), (1020, 0), (1025, 0)]
Vdin0_2  din0_2  0 PWL (0n 0.0v 4.745n 0.0v 4.755n 1.0v 9.745n 1.0v 9.755n 1.0v 14.745n 1.0v 14.755n 0.0v 19.745n 0.0v 19.755n 0.0v 24.745n 0.0v 24.755n 0.0v 29.745n 0.0v 29.755n 0.0v 34.745n 0.0v 34.755n 0.0v 39.745n 0.0v 39.755n 0.0v 44.745n 0.0v 44.755n 0.0v 49.745n 0.0v 49.755n 0.0v 54.745n 0.0v 54.755n 0.0v 59.745n 0.0v 59.755n 0.0v 64.745n 0.0v 64.755n 0.0v 69.745n 0.0v 69.755n 0.0v 74.745n 0.0v 74.755n 0.0v 79.745n 0.0v 79.755n 0.0v 84.745n 0.0v 84.755n 0.0v 89.745n 0.0v 89.755n 0.0v 94.745n 0.0v 94.755n 0.0v 99.745n 0.0v 99.755n 0.0v 104.745n 0.0v 104.755n 0.0v 109.745n 0.0v 109.755n 0.0v 114.745n 0.0v 114.755n 0.0v 119.745n 0.0v 119.755n 1.0v 124.745n 1.0v 124.755n 1.0v 129.745n 1.0v 129.755n 1.0v 134.745n 1.0v 134.755n 1.0v 139.745n 1.0v 139.755n 1.0v 144.745n 1.0v 144.755n 1.0v 149.745n 1.0v 149.755n 1.0v 154.745n 1.0v 154.755n 1.0v 159.745n 1.0v 159.755n 1.0v 164.745n 1.0v 164.755n 1.0v 169.745n 1.0v 169.755n 1.0v 174.745n 1.0v 174.755n 1.0v 179.745n 1.0v 179.755n 1.0v 184.745n 1.0v 184.755n 1.0v 189.745n 1.0v 189.755n 1.0v 194.745n 1.0v 194.755n 1.0v 199.745n 1.0v 199.755n 0.0v 204.745n 0.0v 204.755n 1.0v 209.745n 1.0v 209.755n 1.0v 214.745n 1.0v 214.755n 1.0v 219.745n 1.0v 219.755n 1.0v 224.745n 1.0v 224.755n 1.0v 229.745n 1.0v 229.755n 1.0v 234.745n 1.0v 234.755n 1.0v 239.745n 1.0v 239.755n 1.0v 244.745n 1.0v 244.755n 1.0v 249.745n 1.0v 249.755n 1.0v 254.745n 1.0v 254.755n 0.0v 259.745n 0.0v 259.755n 0.0v 264.745n 0.0v 264.755n 0.0v 269.745n 0.0v 269.755n 0.0v 274.745n 0.0v 274.755n 0.0v 279.745n 0.0v 279.755n 0.0v 284.745n 0.0v 284.755n 1.0v 289.745n 1.0v 289.755n 1.0v 294.745n 1.0v 294.755n 1.0v 299.745n 1.0v 299.755n 1.0v 304.745n 1.0v 304.755n 1.0v 309.745n 1.0v 309.755n 1.0v 314.745n 1.0v 314.755n 1.0v 319.745n 1.0v 319.755n 0.0v 324.745n 0.0v 324.755n 0.0v 329.745n 0.0v 329.755n 0.0v 334.745n 0.0v 334.755n 0.0v 339.745n 0.0v 339.755n 0.0v 344.745n 0.0v 344.755n 0.0v 349.745n 0.0v 349.755n 0.0v 354.745n 0.0v 354.755n 0.0v 359.745n 0.0v 359.755n 0.0v 364.745n 0.0v 364.755n 0.0v 369.745n 0.0v 369.755n 0.0v 374.745n 0.0v 374.755n 0.0v 379.745n 0.0v 379.755n 0.0v 384.745n 0.0v 384.755n 0.0v 389.745n 0.0v 389.755n 0.0v 394.745n 0.0v 394.755n 0.0v 399.745n 0.0v 399.755n 0.0v 404.745n 0.0v 404.755n 0.0v 409.745n 0.0v 409.755n 1.0v 414.745n 1.0v 414.755n 1.0v 419.745n 1.0v 419.755n 1.0v 424.745n 1.0v 424.755n 1.0v 429.745n 1.0v 429.755n 1.0v 434.745n 1.0v 434.755n 1.0v 439.745n 1.0v 439.755n 1.0v 444.745n 1.0v 444.755n 0.0v 449.745n 0.0v 449.755n 1.0v 454.745n 1.0v 454.755n 0.0v 459.745n 0.0v 459.755n 0.0v 464.745n 0.0v 464.755n 0.0v 469.745n 0.0v 469.755n 0.0v 474.745n 0.0v 474.755n 1.0v 479.745n 1.0v 479.755n 1.0v 484.745n 1.0v 484.755n 1.0v 489.745n 1.0v 489.755n 1.0v 494.745n 1.0v 494.755n 1.0v 499.745n 1.0v 499.755n 1.0v 504.745n 1.0v 504.755n 1.0v 509.745n 1.0v 509.755n 1.0v 514.745n 1.0v 514.755n 1.0v 519.745n 1.0v 519.755n 0.0v 524.745n 0.0v 524.755n 0.0v 529.745n 0.0v 529.755n 0.0v 534.745n 0.0v 534.755n 0.0v 539.745n 0.0v 539.755n 0.0v 544.745n 0.0v 544.755n 0.0v 549.745n 0.0v 549.755n 0.0v 554.745n 0.0v 554.755n 0.0v 559.745n 0.0v 559.755n 0.0v 564.745n 0.0v 564.755n 0.0v 569.745n 0.0v 569.755n 0.0v 574.745n 0.0v 574.755n 0.0v 579.745n 0.0v 579.755n 0.0v 584.745n 0.0v 584.755n 0.0v 589.745n 0.0v 589.755n 0.0v 594.745n 0.0v 594.755n 0.0v 599.745n 0.0v 599.755n 0.0v 604.745n 0.0v 604.755n 0.0v 609.745n 0.0v 609.755n 0.0v 614.745n 0.0v 614.755n 0.0v 619.745n 0.0v 619.755n 0.0v 624.745n 0.0v 624.755n 0.0v 629.745n 0.0v 629.755n 0.0v 634.745n 0.0v 634.755n 0.0v 639.745n 0.0v 639.755n 0.0v 644.745n 0.0v 644.755n 0.0v 649.745n 0.0v 649.755n 0.0v 654.745n 0.0v 654.755n 1.0v 659.745n 1.0v 659.755n 1.0v 664.745n 1.0v 664.755n 0.0v 669.745n 0.0v 669.755n 0.0v 674.745n 0.0v 674.755n 1.0v 679.745n 1.0v 679.755n 1.0v 684.745n 1.0v 684.755n 1.0v 689.745n 1.0v 689.755n 1.0v 694.745n 1.0v 694.755n 1.0v 699.745n 1.0v 699.755n 1.0v 704.745n 1.0v 704.755n 1.0v 709.745n 1.0v 709.755n 1.0v 714.745n 1.0v 714.755n 0.0v 719.745n 0.0v 719.755n 0.0v 724.745n 0.0v 724.755n 0.0v 729.745n 0.0v 729.755n 0.0v 734.745n 0.0v 734.755n 0.0v 739.745n 0.0v 739.755n 0.0v 744.745n 0.0v 744.755n 0.0v 749.745n 0.0v 749.755n 1.0v 754.745n 1.0v 754.755n 1.0v 759.745n 1.0v 759.755n 1.0v 764.745n 1.0v 764.755n 1.0v 769.745n 1.0v 769.755n 1.0v 774.745n 1.0v 774.755n 1.0v 779.745n 1.0v 779.755n 1.0v 784.745n 1.0v 784.755n 1.0v 789.745n 1.0v 789.755n 1.0v 794.745n 1.0v 794.755n 0.0v 799.745n 0.0v 799.755n 1.0v 804.745n 1.0v 804.755n 1.0v 809.745n 1.0v 809.755n 1.0v 814.745n 1.0v 814.755n 1.0v 819.745n 1.0v 819.755n 1.0v 824.745n 1.0v 824.755n 1.0v 829.745n 1.0v 829.755n 1.0v 834.745n 1.0v 834.755n 1.0v 839.745n 1.0v 839.755n 1.0v 844.745n 1.0v 844.755n 1.0v 849.745n 1.0v 849.755n 1.0v 854.745n 1.0v 854.755n 0.0v 859.745n 0.0v 859.755n 0.0v 864.745n 0.0v 864.755n 0.0v 869.745n 0.0v 869.755n 0.0v 874.745n 0.0v 874.755n 0.0v 879.745n 0.0v 879.755n 0.0v 884.745n 0.0v 884.755n 0.0v 889.745n 0.0v 889.755n 0.0v 894.745n 0.0v 894.755n 1.0v 899.745n 1.0v 899.755n 1.0v 904.745n 1.0v 904.755n 1.0v 909.745n 1.0v 909.755n 1.0v 914.745n 1.0v 914.755n 1.0v 919.745n 1.0v 919.755n 1.0v 924.745n 1.0v 924.755n 1.0v 929.745n 1.0v 929.755n 1.0v 934.745n 1.0v 934.755n 1.0v 939.745n 1.0v 939.755n 1.0v 944.745n 1.0v 944.755n 1.0v 949.745n 1.0v 949.755n 1.0v 954.745n 1.0v 954.755n 1.0v 959.745n 1.0v 959.755n 0.0v 964.745n 0.0v 964.755n 1.0v 969.745n 1.0v 969.755n 1.0v 974.745n 1.0v 974.755n 1.0v 979.745n 1.0v 979.755n 1.0v 984.745n 1.0v 984.755n 1.0v 989.745n 1.0v 989.755n 1.0v 994.745n 1.0v 994.755n 1.0v 999.745n 1.0v 999.755n 1.0v 1004.745n 1.0v 1004.755n 1.0v 1009.745n 1.0v 1009.755n 1.0v 1014.745n 1.0v 1014.755n 0.0v 1019.745n 0.0v 1019.755n 0.0v 1024.745n 0.0v 1024.755n 0.0v )
* (time, data): [(0, 0), (5, 1), (10, 1), (15, 0), (20, 0), (25, 0), (30, 0), (35, 0), (40, 0), (45, 0), (50, 0), (55, 0), (60, 1), (65, 1), (70, 1), (75, 1), (80, 1), (85, 1), (90, 1), (95, 0), (100, 0), (105, 0), (110, 0), (115, 0), (120, 0), (125, 0), (130, 0), (135, 1), (140, 0), (145, 0), (150, 0), (155, 0), (160, 0), (165, 0), (170, 0), (175, 0), (180, 0), (185, 0), (190, 0), (195, 0), (200, 1), (205, 0), (210, 0), (215, 0), (220, 0), (225, 0), (230, 0), (235, 0), (240, 0), (245, 0), (250, 0), (255, 1), (260, 0), (265, 0), (270, 0), (275, 1), (280, 1), (285, 0), (290, 0), (295, 0), (300, 0), (305, 0), (310, 0), (315, 0), (320, 1), (325, 1), (330, 1), (335, 1), (340, 1), (345, 1), (350, 0), (355, 0), (360, 0), (365, 0), (370, 0), (375, 0), (380, 0), (385, 0), (390, 0), (395, 0), (400, 0), (405, 0), (410, 1), (415, 1), (420, 1), (425, 1), (430, 1), (435, 1), (440, 1), (445, 0), (450, 1), (455, 0), (460, 0), (465, 0), (470, 0), (475, 0), (480, 0), (485, 0), (490, 0), (495, 0), (500, 0), (505, 0), (510, 0), (515, 0), (520, 1), (525, 1), (530, 1), (535, 1), (540, 1), (545, 1), (550, 1), (555, 1), (560, 1), (565, 1), (570, 1), (575, 0), (580, 0), (585, 0), (590, 0), (595, 0), (600, 0), (605, 0), (610, 0), (615, 0), (620, 0), (625, 0), (630, 0), (635, 0), (640, 1), (645, 1), (650, 1), (655, 0), (660, 0), (665, 1), (670, 1), (675, 1), (680, 0), (685, 0), (690, 0), (695, 1), (700, 1), (705, 1), (710, 1), (715, 1), (720, 1), (725, 1), (730, 1), (735, 1), (740, 1), (745, 1), (750, 1), (755, 1), (760, 1), (765, 1), (770, 1), (775, 1), (780, 1), (785, 1), (790, 0), (795, 0), (800, 0), (805, 0), (810, 0), (815, 0), (820, 1), (825, 1), (830, 1), (835, 1), (840, 1), (845, 1), (850, 1), (855, 1), (860, 1), (865, 1), (870, 1), (875, 1), (880, 1), (885, 1), (890, 1), (895, 1), (900, 1), (905, 1), (910, 1), (915, 1), (920, 1), (925, 1), (930, 1), (935, 1), (940, 1), (945, 1), (950, 1), (955, 1), (960, 1), (965, 1), (970, 1), (975, 1), (980, 1), (985, 1), (990, 1), (995, 1), (1000, 1), (1005, 1), (1010, 1), (1015, 0), (1020, 0), (1025, 0)]
Vdin0_3  din0_3  0 PWL (0n 0.0v 4.745n 0.0v 4.755n 1.0v 9.745n 1.0v 9.755n 1.0v 14.745n 1.0v 14.755n 0.0v 19.745n 0.0v 19.755n 0.0v 24.745n 0.0v 24.755n 0.0v 29.745n 0.0v 29.755n 0.0v 34.745n 0.0v 34.755n 0.0v 39.745n 0.0v 39.755n 0.0v 44.745n 0.0v 44.755n 0.0v 49.745n 0.0v 49.755n 0.0v 54.745n 0.0v 54.755n 0.0v 59.745n 0.0v 59.755n 1.0v 64.745n 1.0v 64.755n 1.0v 69.745n 1.0v 69.755n 1.0v 74.745n 1.0v 74.755n 1.0v 79.745n 1.0v 79.755n 1.0v 84.745n 1.0v 84.755n 1.0v 89.745n 1.0v 89.755n 1.0v 94.745n 1.0v 94.755n 0.0v 99.745n 0.0v 99.755n 0.0v 104.745n 0.0v 104.755n 0.0v 109.745n 0.0v 109.755n 0.0v 114.745n 0.0v 114.755n 0.0v 119.745n 0.0v 119.755n 0.0v 124.745n 0.0v 124.755n 0.0v 129.745n 0.0v 129.755n 0.0v 134.745n 0.0v 134.755n 1.0v 139.745n 1.0v 139.755n 0.0v 144.745n 0.0v 144.755n 0.0v 149.745n 0.0v 149.755n 0.0v 154.745n 0.0v 154.755n 0.0v 159.745n 0.0v 159.755n 0.0v 164.745n 0.0v 164.755n 0.0v 169.745n 0.0v 169.755n 0.0v 174.745n 0.0v 174.755n 0.0v 179.745n 0.0v 179.755n 0.0v 184.745n 0.0v 184.755n 0.0v 189.745n 0.0v 189.755n 0.0v 194.745n 0.0v 194.755n 0.0v 199.745n 0.0v 199.755n 1.0v 204.745n 1.0v 204.755n 0.0v 209.745n 0.0v 209.755n 0.0v 214.745n 0.0v 214.755n 0.0v 219.745n 0.0v 219.755n 0.0v 224.745n 0.0v 224.755n 0.0v 229.745n 0.0v 229.755n 0.0v 234.745n 0.0v 234.755n 0.0v 239.745n 0.0v 239.755n 0.0v 244.745n 0.0v 244.755n 0.0v 249.745n 0.0v 249.755n 0.0v 254.745n 0.0v 254.755n 1.0v 259.745n 1.0v 259.755n 0.0v 264.745n 0.0v 264.755n 0.0v 269.745n 0.0v 269.755n 0.0v 274.745n 0.0v 274.755n 1.0v 279.745n 1.0v 279.755n 1.0v 284.745n 1.0v 284.755n 0.0v 289.745n 0.0v 289.755n 0.0v 294.745n 0.0v 294.755n 0.0v 299.745n 0.0v 299.755n 0.0v 304.745n 0.0v 304.755n 0.0v 309.745n 0.0v 309.755n 0.0v 314.745n 0.0v 314.755n 0.0v 319.745n 0.0v 319.755n 1.0v 324.745n 1.0v 324.755n 1.0v 329.745n 1.0v 329.755n 1.0v 334.745n 1.0v 334.755n 1.0v 339.745n 1.0v 339.755n 1.0v 344.745n 1.0v 344.755n 1.0v 349.745n 1.0v 349.755n 0.0v 354.745n 0.0v 354.755n 0.0v 359.745n 0.0v 359.755n 0.0v 364.745n 0.0v 364.755n 0.0v 369.745n 0.0v 369.755n 0.0v 374.745n 0.0v 374.755n 0.0v 379.745n 0.0v 379.755n 0.0v 384.745n 0.0v 384.755n 0.0v 389.745n 0.0v 389.755n 0.0v 394.745n 0.0v 394.755n 0.0v 399.745n 0.0v 399.755n 0.0v 404.745n 0.0v 404.755n 0.0v 409.745n 0.0v 409.755n 1.0v 414.745n 1.0v 414.755n 1.0v 419.745n 1.0v 419.755n 1.0v 424.745n 1.0v 424.755n 1.0v 429.745n 1.0v 429.755n 1.0v 434.745n 1.0v 434.755n 1.0v 439.745n 1.0v 439.755n 1.0v 444.745n 1.0v 444.755n 0.0v 449.745n 0.0v 449.755n 1.0v 454.745n 1.0v 454.755n 0.0v 459.745n 0.0v 459.755n 0.0v 464.745n 0.0v 464.755n 0.0v 469.745n 0.0v 469.755n 0.0v 474.745n 0.0v 474.755n 0.0v 479.745n 0.0v 479.755n 0.0v 484.745n 0.0v 484.755n 0.0v 489.745n 0.0v 489.755n 0.0v 494.745n 0.0v 494.755n 0.0v 499.745n 0.0v 499.755n 0.0v 504.745n 0.0v 504.755n 0.0v 509.745n 0.0v 509.755n 0.0v 514.745n 0.0v 514.755n 0.0v 519.745n 0.0v 519.755n 1.0v 524.745n 1.0v 524.755n 1.0v 529.745n 1.0v 529.755n 1.0v 534.745n 1.0v 534.755n 1.0v 539.745n 1.0v 539.755n 1.0v 544.745n 1.0v 544.755n 1.0v 549.745n 1.0v 549.755n 1.0v 554.745n 1.0v 554.755n 1.0v 559.745n 1.0v 559.755n 1.0v 564.745n 1.0v 564.755n 1.0v 569.745n 1.0v 569.755n 1.0v 574.745n 1.0v 574.755n 0.0v 579.745n 0.0v 579.755n 0.0v 584.745n 0.0v 584.755n 0.0v 589.745n 0.0v 589.755n 0.0v 594.745n 0.0v 594.755n 0.0v 599.745n 0.0v 599.755n 0.0v 604.745n 0.0v 604.755n 0.0v 609.745n 0.0v 609.755n 0.0v 614.745n 0.0v 614.755n 0.0v 619.745n 0.0v 619.755n 0.0v 624.745n 0.0v 624.755n 0.0v 629.745n 0.0v 629.755n 0.0v 634.745n 0.0v 634.755n 0.0v 639.745n 0.0v 639.755n 1.0v 644.745n 1.0v 644.755n 1.0v 649.745n 1.0v 649.755n 1.0v 654.745n 1.0v 654.755n 0.0v 659.745n 0.0v 659.755n 0.0v 664.745n 0.0v 664.755n 1.0v 669.745n 1.0v 669.755n 1.0v 674.745n 1.0v 674.755n 1.0v 679.745n 1.0v 679.755n 0.0v 684.745n 0.0v 684.755n 0.0v 689.745n 0.0v 689.755n 0.0v 694.745n 0.0v 694.755n 1.0v 699.745n 1.0v 699.755n 1.0v 704.745n 1.0v 704.755n 1.0v 709.745n 1.0v 709.755n 1.0v 714.745n 1.0v 714.755n 1.0v 719.745n 1.0v 719.755n 1.0v 724.745n 1.0v 724.755n 1.0v 729.745n 1.0v 729.755n 1.0v 734.745n 1.0v 734.755n 1.0v 739.745n 1.0v 739.755n 1.0v 744.745n 1.0v 744.755n 1.0v 749.745n 1.0v 749.755n 1.0v 754.745n 1.0v 754.755n 1.0v 759.745n 1.0v 759.755n 1.0v 764.745n 1.0v 764.755n 1.0v 769.745n 1.0v 769.755n 1.0v 774.745n 1.0v 774.755n 1.0v 779.745n 1.0v 779.755n 1.0v 784.745n 1.0v 784.755n 1.0v 789.745n 1.0v 789.755n 0.0v 794.745n 0.0v 794.755n 0.0v 799.745n 0.0v 799.755n 0.0v 804.745n 0.0v 804.755n 0.0v 809.745n 0.0v 809.755n 0.0v 814.745n 0.0v 814.755n 0.0v 819.745n 0.0v 819.755n 1.0v 824.745n 1.0v 824.755n 1.0v 829.745n 1.0v 829.755n 1.0v 834.745n 1.0v 834.755n 1.0v 839.745n 1.0v 839.755n 1.0v 844.745n 1.0v 844.755n 1.0v 849.745n 1.0v 849.755n 1.0v 854.745n 1.0v 854.755n 1.0v 859.745n 1.0v 859.755n 1.0v 864.745n 1.0v 864.755n 1.0v 869.745n 1.0v 869.755n 1.0v 874.745n 1.0v 874.755n 1.0v 879.745n 1.0v 879.755n 1.0v 884.745n 1.0v 884.755n 1.0v 889.745n 1.0v 889.755n 1.0v 894.745n 1.0v 894.755n 1.0v 899.745n 1.0v 899.755n 1.0v 904.745n 1.0v 904.755n 1.0v 909.745n 1.0v 909.755n 1.0v 914.745n 1.0v 914.755n 1.0v 919.745n 1.0v 919.755n 1.0v 924.745n 1.0v 924.755n 1.0v 929.745n 1.0v 929.755n 1.0v 934.745n 1.0v 934.755n 1.0v 939.745n 1.0v 939.755n 1.0v 944.745n 1.0v 944.755n 1.0v 949.745n 1.0v 949.755n 1.0v 954.745n 1.0v 954.755n 1.0v 959.745n 1.0v 959.755n 1.0v 964.745n 1.0v 964.755n 1.0v 969.745n 1.0v 969.755n 1.0v 974.745n 1.0v 974.755n 1.0v 979.745n 1.0v 979.755n 1.0v 984.745n 1.0v 984.755n 1.0v 989.745n 1.0v 989.755n 1.0v 994.745n 1.0v 994.755n 1.0v 999.745n 1.0v 999.755n 1.0v 1004.745n 1.0v 1004.755n 1.0v 1009.745n 1.0v 1009.755n 1.0v 1014.745n 1.0v 1014.755n 0.0v 1019.745n 0.0v 1019.755n 0.0v 1024.745n 0.0v 1024.755n 0.0v )
* (time, data): [(0, 0), (5, 1), (10, 0), (15, 0), (20, 0), (25, 0), (30, 0), (35, 0), (40, 0), (45, 0), (50, 0), (55, 0), (60, 0), (65, 0), (70, 0), (75, 1), (80, 1), (85, 1), (90, 1), (95, 0), (100, 0), (105, 0), (110, 0), (115, 0), (120, 1), (125, 1), (130, 1), (135, 1), (140, 0), (145, 0), (150, 0), (155, 0), (160, 0), (165, 0), (170, 0), (175, 0), (180, 0), (185, 0), (190, 0), (195, 0), (200, 1), (205, 0), (210, 0), (215, 0), (220, 0), (225, 0), (230, 0), (235, 0), (240, 0), (245, 0), (250, 0), (255, 0), (260, 0), (265, 0), (270, 0), (275, 0), (280, 0), (285, 0), (290, 0), (295, 0), (300, 0), (305, 0), (310, 0), (315, 0), (320, 1), (325, 1), (330, 1), (335, 1), (340, 1), (345, 0), (350, 1), (355, 1), (360, 1), (365, 1), (370, 1), (375, 1), (380, 1), (385, 1), (390, 1), (395, 1), (400, 1), (405, 1), (410, 0), (415, 0), (420, 0), (425, 0), (430, 0), (435, 0), (440, 0), (445, 0), (450, 0), (455, 1), (460, 1), (465, 1), (470, 1), (475, 1), (480, 1), (485, 1), (490, 1), (495, 1), (500, 1), (505, 1), (510, 1), (515, 1), (520, 1), (525, 1), (530, 1), (535, 1), (540, 1), (545, 1), (550, 1), (555, 1), (560, 1), (565, 1), (570, 1), (575, 0), (580, 0), (585, 0), (590, 0), (595, 0), (600, 0), (605, 0), (610, 0), (615, 0), (620, 0), (625, 0), (630, 1), (635, 1), (640, 0), (645, 0), (650, 0), (655, 0), (660, 0), (665, 1), (670, 1), (675, 0), (680, 1), (685, 1), (690, 1), (695, 1), (700, 1), (705, 1), (710, 1), (715, 0), (720, 0), (725, 0), (730, 0), (735, 0), (740, 0), (745, 0), (750, 1), (755, 1), (760, 1), (765, 1), (770, 1), (775, 1), (780, 1), (785, 1), (790, 1), (795, 0), (800, 1), (805, 1), (810, 1), (815, 1), (820, 0), (825, 0), (830, 0), (835, 0), (840, 0), (845, 0), (850, 0), (855, 1), (860, 1), (865, 1), (870, 1), (875, 1), (880, 1), (885, 1), (890, 1), (895, 1), (900, 1), (905, 1), (910, 1), (915, 0), (920, 0), (925, 0), (930, 1), (935, 1), (940, 1), (945, 1), (950, 1), (955, 1), (960, 0), (965, 0), (970, 0), (975, 0), (980, 0), (985, 0), (990, 0), (995, 0), (1000, 0), (1005, 0), (1010, 0), (1015, 0), (1020, 0), (1025, 0)]
Vdin0_4  din0_4  0 PWL (0n 0.0v 4.745n 0.0v 4.755n 1.0v 9.745n 1.0v 9.755n 0.0v 14.745n 0.0v 14.755n 0.0v 19.745n 0.0v 19.755n 0.0v 24.745n 0.0v 24.755n 0.0v 29.745n 0.0v 29.755n 0.0v 34.745n 0.0v 34.755n 0.0v 39.745n 0.0v 39.755n 0.0v 44.745n 0.0v 44.755n 0.0v 49.745n 0.0v 49.755n 0.0v 54.745n 0.0v 54.755n 0.0v 59.745n 0.0v 59.755n 0.0v 64.745n 0.0v 64.755n 0.0v 69.745n 0.0v 69.755n 0.0v 74.745n 0.0v 74.755n 1.0v 79.745n 1.0v 79.755n 1.0v 84.745n 1.0v 84.755n 1.0v 89.745n 1.0v 89.755n 1.0v 94.745n 1.0v 94.755n 0.0v 99.745n 0.0v 99.755n 0.0v 104.745n 0.0v 104.755n 0.0v 109.745n 0.0v 109.755n 0.0v 114.745n 0.0v 114.755n 0.0v 119.745n 0.0v 119.755n 1.0v 124.745n 1.0v 124.755n 1.0v 129.745n 1.0v 129.755n 1.0v 134.745n 1.0v 134.755n 1.0v 139.745n 1.0v 139.755n 0.0v 144.745n 0.0v 144.755n 0.0v 149.745n 0.0v 149.755n 0.0v 154.745n 0.0v 154.755n 0.0v 159.745n 0.0v 159.755n 0.0v 164.745n 0.0v 164.755n 0.0v 169.745n 0.0v 169.755n 0.0v 174.745n 0.0v 174.755n 0.0v 179.745n 0.0v 179.755n 0.0v 184.745n 0.0v 184.755n 0.0v 189.745n 0.0v 189.755n 0.0v 194.745n 0.0v 194.755n 0.0v 199.745n 0.0v 199.755n 1.0v 204.745n 1.0v 204.755n 0.0v 209.745n 0.0v 209.755n 0.0v 214.745n 0.0v 214.755n 0.0v 219.745n 0.0v 219.755n 0.0v 224.745n 0.0v 224.755n 0.0v 229.745n 0.0v 229.755n 0.0v 234.745n 0.0v 234.755n 0.0v 239.745n 0.0v 239.755n 0.0v 244.745n 0.0v 244.755n 0.0v 249.745n 0.0v 249.755n 0.0v 254.745n 0.0v 254.755n 0.0v 259.745n 0.0v 259.755n 0.0v 264.745n 0.0v 264.755n 0.0v 269.745n 0.0v 269.755n 0.0v 274.745n 0.0v 274.755n 0.0v 279.745n 0.0v 279.755n 0.0v 284.745n 0.0v 284.755n 0.0v 289.745n 0.0v 289.755n 0.0v 294.745n 0.0v 294.755n 0.0v 299.745n 0.0v 299.755n 0.0v 304.745n 0.0v 304.755n 0.0v 309.745n 0.0v 309.755n 0.0v 314.745n 0.0v 314.755n 0.0v 319.745n 0.0v 319.755n 1.0v 324.745n 1.0v 324.755n 1.0v 329.745n 1.0v 329.755n 1.0v 334.745n 1.0v 334.755n 1.0v 339.745n 1.0v 339.755n 1.0v 344.745n 1.0v 344.755n 0.0v 349.745n 0.0v 349.755n 1.0v 354.745n 1.0v 354.755n 1.0v 359.745n 1.0v 359.755n 1.0v 364.745n 1.0v 364.755n 1.0v 369.745n 1.0v 369.755n 1.0v 374.745n 1.0v 374.755n 1.0v 379.745n 1.0v 379.755n 1.0v 384.745n 1.0v 384.755n 1.0v 389.745n 1.0v 389.755n 1.0v 394.745n 1.0v 394.755n 1.0v 399.745n 1.0v 399.755n 1.0v 404.745n 1.0v 404.755n 1.0v 409.745n 1.0v 409.755n 0.0v 414.745n 0.0v 414.755n 0.0v 419.745n 0.0v 419.755n 0.0v 424.745n 0.0v 424.755n 0.0v 429.745n 0.0v 429.755n 0.0v 434.745n 0.0v 434.755n 0.0v 439.745n 0.0v 439.755n 0.0v 444.745n 0.0v 444.755n 0.0v 449.745n 0.0v 449.755n 0.0v 454.745n 0.0v 454.755n 1.0v 459.745n 1.0v 459.755n 1.0v 464.745n 1.0v 464.755n 1.0v 469.745n 1.0v 469.755n 1.0v 474.745n 1.0v 474.755n 1.0v 479.745n 1.0v 479.755n 1.0v 484.745n 1.0v 484.755n 1.0v 489.745n 1.0v 489.755n 1.0v 494.745n 1.0v 494.755n 1.0v 499.745n 1.0v 499.755n 1.0v 504.745n 1.0v 504.755n 1.0v 509.745n 1.0v 509.755n 1.0v 514.745n 1.0v 514.755n 1.0v 519.745n 1.0v 519.755n 1.0v 524.745n 1.0v 524.755n 1.0v 529.745n 1.0v 529.755n 1.0v 534.745n 1.0v 534.755n 1.0v 539.745n 1.0v 539.755n 1.0v 544.745n 1.0v 544.755n 1.0v 549.745n 1.0v 549.755n 1.0v 554.745n 1.0v 554.755n 1.0v 559.745n 1.0v 559.755n 1.0v 564.745n 1.0v 564.755n 1.0v 569.745n 1.0v 569.755n 1.0v 574.745n 1.0v 574.755n 0.0v 579.745n 0.0v 579.755n 0.0v 584.745n 0.0v 584.755n 0.0v 589.745n 0.0v 589.755n 0.0v 594.745n 0.0v 594.755n 0.0v 599.745n 0.0v 599.755n 0.0v 604.745n 0.0v 604.755n 0.0v 609.745n 0.0v 609.755n 0.0v 614.745n 0.0v 614.755n 0.0v 619.745n 0.0v 619.755n 0.0v 624.745n 0.0v 624.755n 0.0v 629.745n 0.0v 629.755n 1.0v 634.745n 1.0v 634.755n 1.0v 639.745n 1.0v 639.755n 0.0v 644.745n 0.0v 644.755n 0.0v 649.745n 0.0v 649.755n 0.0v 654.745n 0.0v 654.755n 0.0v 659.745n 0.0v 659.755n 0.0v 664.745n 0.0v 664.755n 1.0v 669.745n 1.0v 669.755n 1.0v 674.745n 1.0v 674.755n 0.0v 679.745n 0.0v 679.755n 1.0v 684.745n 1.0v 684.755n 1.0v 689.745n 1.0v 689.755n 1.0v 694.745n 1.0v 694.755n 1.0v 699.745n 1.0v 699.755n 1.0v 704.745n 1.0v 704.755n 1.0v 709.745n 1.0v 709.755n 1.0v 714.745n 1.0v 714.755n 0.0v 719.745n 0.0v 719.755n 0.0v 724.745n 0.0v 724.755n 0.0v 729.745n 0.0v 729.755n 0.0v 734.745n 0.0v 734.755n 0.0v 739.745n 0.0v 739.755n 0.0v 744.745n 0.0v 744.755n 0.0v 749.745n 0.0v 749.755n 1.0v 754.745n 1.0v 754.755n 1.0v 759.745n 1.0v 759.755n 1.0v 764.745n 1.0v 764.755n 1.0v 769.745n 1.0v 769.755n 1.0v 774.745n 1.0v 774.755n 1.0v 779.745n 1.0v 779.755n 1.0v 784.745n 1.0v 784.755n 1.0v 789.745n 1.0v 789.755n 1.0v 794.745n 1.0v 794.755n 0.0v 799.745n 0.0v 799.755n 1.0v 804.745n 1.0v 804.755n 1.0v 809.745n 1.0v 809.755n 1.0v 814.745n 1.0v 814.755n 1.0v 819.745n 1.0v 819.755n 0.0v 824.745n 0.0v 824.755n 0.0v 829.745n 0.0v 829.755n 0.0v 834.745n 0.0v 834.755n 0.0v 839.745n 0.0v 839.755n 0.0v 844.745n 0.0v 844.755n 0.0v 849.745n 0.0v 849.755n 0.0v 854.745n 0.0v 854.755n 1.0v 859.745n 1.0v 859.755n 1.0v 864.745n 1.0v 864.755n 1.0v 869.745n 1.0v 869.755n 1.0v 874.745n 1.0v 874.755n 1.0v 879.745n 1.0v 879.755n 1.0v 884.745n 1.0v 884.755n 1.0v 889.745n 1.0v 889.755n 1.0v 894.745n 1.0v 894.755n 1.0v 899.745n 1.0v 899.755n 1.0v 904.745n 1.0v 904.755n 1.0v 909.745n 1.0v 909.755n 1.0v 914.745n 1.0v 914.755n 0.0v 919.745n 0.0v 919.755n 0.0v 924.745n 0.0v 924.755n 0.0v 929.745n 0.0v 929.755n 1.0v 934.745n 1.0v 934.755n 1.0v 939.745n 1.0v 939.755n 1.0v 944.745n 1.0v 944.755n 1.0v 949.745n 1.0v 949.755n 1.0v 954.745n 1.0v 954.755n 1.0v 959.745n 1.0v 959.755n 0.0v 964.745n 0.0v 964.755n 0.0v 969.745n 0.0v 969.755n 0.0v 974.745n 0.0v 974.755n 0.0v 979.745n 0.0v 979.755n 0.0v 984.745n 0.0v 984.755n 0.0v 989.745n 0.0v 989.755n 0.0v 994.745n 0.0v 994.755n 0.0v 999.745n 0.0v 999.755n 0.0v 1004.745n 0.0v 1004.755n 0.0v 1009.745n 0.0v 1009.755n 0.0v 1014.745n 0.0v 1014.755n 0.0v 1019.745n 0.0v 1019.755n 0.0v 1024.745n 0.0v 1024.755n 0.0v )
* (time, data): [(0, 0), (5, 1), (10, 0), (15, 0), (20, 0), (25, 0), (30, 0), (35, 0), (40, 0), (45, 0), (50, 0), (55, 0), (60, 1), (65, 1), (70, 1), (75, 0), (80, 0), (85, 0), (90, 0), (95, 1), (100, 1), (105, 1), (110, 1), (115, 1), (120, 1), (125, 1), (130, 1), (135, 1), (140, 0), (145, 0), (150, 0), (155, 0), (160, 0), (165, 0), (170, 0), (175, 0), (180, 0), (185, 0), (190, 0), (195, 0), (200, 1), (205, 0), (210, 0), (215, 0), (220, 0), (225, 0), (230, 0), (235, 0), (240, 0), (245, 0), (250, 0), (255, 1), (260, 1), (265, 1), (270, 1), (275, 0), (280, 0), (285, 0), (290, 0), (295, 0), (300, 0), (305, 0), (310, 0), (315, 0), (320, 1), (325, 1), (330, 1), (335, 1), (340, 1), (345, 0), (350, 0), (355, 0), (360, 0), (365, 0), (370, 0), (375, 0), (380, 0), (385, 0), (390, 0), (395, 0), (400, 0), (405, 0), (410, 0), (415, 0), (420, 0), (425, 0), (430, 0), (435, 0), (440, 0), (445, 1), (450, 0), (455, 0), (460, 0), (465, 0), (470, 0), (475, 0), (480, 0), (485, 0), (490, 0), (495, 0), (500, 0), (505, 0), (510, 0), (515, 0), (520, 1), (525, 1), (530, 1), (535, 1), (540, 1), (545, 1), (550, 1), (555, 1), (560, 1), (565, 1), (570, 1), (575, 0), (580, 0), (585, 0), (590, 0), (595, 1), (600, 1), (605, 1), (610, 1), (615, 1), (620, 1), (625, 1), (630, 1), (635, 1), (640, 0), (645, 0), (650, 0), (655, 1), (660, 1), (665, 1), (670, 1), (675, 0), (680, 1), (685, 1), (690, 1), (695, 1), (700, 1), (705, 1), (710, 1), (715, 0), (720, 0), (725, 0), (730, 0), (735, 0), (740, 0), (745, 0), (750, 0), (755, 0), (760, 0), (765, 0), (770, 0), (775, 0), (780, 0), (785, 0), (790, 1), (795, 0), (800, 1), (805, 1), (810, 1), (815, 1), (820, 0), (825, 0), (830, 0), (835, 0), (840, 0), (845, 0), (850, 0), (855, 0), (860, 0), (865, 0), (870, 0), (875, 0), (880, 0), (885, 0), (890, 0), (895, 1), (900, 1), (905, 0), (910, 0), (915, 1), (920, 0), (925, 0), (930, 0), (935, 0), (940, 0), (945, 0), (950, 0), (955, 0), (960, 1), (965, 1), (970, 1), (975, 1), (980, 1), (985, 1), (990, 1), (995, 1), (1000, 1), (1005, 1), (1010, 1), (1015, 0), (1020, 0), (1025, 0)]
Vdin0_5  din0_5  0 PWL (0n 0.0v 4.745n 0.0v 4.755n 1.0v 9.745n 1.0v 9.755n 0.0v 14.745n 0.0v 14.755n 0.0v 19.745n 0.0v 19.755n 0.0v 24.745n 0.0v 24.755n 0.0v 29.745n 0.0v 29.755n 0.0v 34.745n 0.0v 34.755n 0.0v 39.745n 0.0v 39.755n 0.0v 44.745n 0.0v 44.755n 0.0v 49.745n 0.0v 49.755n 0.0v 54.745n 0.0v 54.755n 0.0v 59.745n 0.0v 59.755n 1.0v 64.745n 1.0v 64.755n 1.0v 69.745n 1.0v 69.755n 1.0v 74.745n 1.0v 74.755n 0.0v 79.745n 0.0v 79.755n 0.0v 84.745n 0.0v 84.755n 0.0v 89.745n 0.0v 89.755n 0.0v 94.745n 0.0v 94.755n 1.0v 99.745n 1.0v 99.755n 1.0v 104.745n 1.0v 104.755n 1.0v 109.745n 1.0v 109.755n 1.0v 114.745n 1.0v 114.755n 1.0v 119.745n 1.0v 119.755n 1.0v 124.745n 1.0v 124.755n 1.0v 129.745n 1.0v 129.755n 1.0v 134.745n 1.0v 134.755n 1.0v 139.745n 1.0v 139.755n 0.0v 144.745n 0.0v 144.755n 0.0v 149.745n 0.0v 149.755n 0.0v 154.745n 0.0v 154.755n 0.0v 159.745n 0.0v 159.755n 0.0v 164.745n 0.0v 164.755n 0.0v 169.745n 0.0v 169.755n 0.0v 174.745n 0.0v 174.755n 0.0v 179.745n 0.0v 179.755n 0.0v 184.745n 0.0v 184.755n 0.0v 189.745n 0.0v 189.755n 0.0v 194.745n 0.0v 194.755n 0.0v 199.745n 0.0v 199.755n 1.0v 204.745n 1.0v 204.755n 0.0v 209.745n 0.0v 209.755n 0.0v 214.745n 0.0v 214.755n 0.0v 219.745n 0.0v 219.755n 0.0v 224.745n 0.0v 224.755n 0.0v 229.745n 0.0v 229.755n 0.0v 234.745n 0.0v 234.755n 0.0v 239.745n 0.0v 239.755n 0.0v 244.745n 0.0v 244.755n 0.0v 249.745n 0.0v 249.755n 0.0v 254.745n 0.0v 254.755n 1.0v 259.745n 1.0v 259.755n 1.0v 264.745n 1.0v 264.755n 1.0v 269.745n 1.0v 269.755n 1.0v 274.745n 1.0v 274.755n 0.0v 279.745n 0.0v 279.755n 0.0v 284.745n 0.0v 284.755n 0.0v 289.745n 0.0v 289.755n 0.0v 294.745n 0.0v 294.755n 0.0v 299.745n 0.0v 299.755n 0.0v 304.745n 0.0v 304.755n 0.0v 309.745n 0.0v 309.755n 0.0v 314.745n 0.0v 314.755n 0.0v 319.745n 0.0v 319.755n 1.0v 324.745n 1.0v 324.755n 1.0v 329.745n 1.0v 329.755n 1.0v 334.745n 1.0v 334.755n 1.0v 339.745n 1.0v 339.755n 1.0v 344.745n 1.0v 344.755n 0.0v 349.745n 0.0v 349.755n 0.0v 354.745n 0.0v 354.755n 0.0v 359.745n 0.0v 359.755n 0.0v 364.745n 0.0v 364.755n 0.0v 369.745n 0.0v 369.755n 0.0v 374.745n 0.0v 374.755n 0.0v 379.745n 0.0v 379.755n 0.0v 384.745n 0.0v 384.755n 0.0v 389.745n 0.0v 389.755n 0.0v 394.745n 0.0v 394.755n 0.0v 399.745n 0.0v 399.755n 0.0v 404.745n 0.0v 404.755n 0.0v 409.745n 0.0v 409.755n 0.0v 414.745n 0.0v 414.755n 0.0v 419.745n 0.0v 419.755n 0.0v 424.745n 0.0v 424.755n 0.0v 429.745n 0.0v 429.755n 0.0v 434.745n 0.0v 434.755n 0.0v 439.745n 0.0v 439.755n 0.0v 444.745n 0.0v 444.755n 1.0v 449.745n 1.0v 449.755n 0.0v 454.745n 0.0v 454.755n 0.0v 459.745n 0.0v 459.755n 0.0v 464.745n 0.0v 464.755n 0.0v 469.745n 0.0v 469.755n 0.0v 474.745n 0.0v 474.755n 0.0v 479.745n 0.0v 479.755n 0.0v 484.745n 0.0v 484.755n 0.0v 489.745n 0.0v 489.755n 0.0v 494.745n 0.0v 494.755n 0.0v 499.745n 0.0v 499.755n 0.0v 504.745n 0.0v 504.755n 0.0v 509.745n 0.0v 509.755n 0.0v 514.745n 0.0v 514.755n 0.0v 519.745n 0.0v 519.755n 1.0v 524.745n 1.0v 524.755n 1.0v 529.745n 1.0v 529.755n 1.0v 534.745n 1.0v 534.755n 1.0v 539.745n 1.0v 539.755n 1.0v 544.745n 1.0v 544.755n 1.0v 549.745n 1.0v 549.755n 1.0v 554.745n 1.0v 554.755n 1.0v 559.745n 1.0v 559.755n 1.0v 564.745n 1.0v 564.755n 1.0v 569.745n 1.0v 569.755n 1.0v 574.745n 1.0v 574.755n 0.0v 579.745n 0.0v 579.755n 0.0v 584.745n 0.0v 584.755n 0.0v 589.745n 0.0v 589.755n 0.0v 594.745n 0.0v 594.755n 1.0v 599.745n 1.0v 599.755n 1.0v 604.745n 1.0v 604.755n 1.0v 609.745n 1.0v 609.755n 1.0v 614.745n 1.0v 614.755n 1.0v 619.745n 1.0v 619.755n 1.0v 624.745n 1.0v 624.755n 1.0v 629.745n 1.0v 629.755n 1.0v 634.745n 1.0v 634.755n 1.0v 639.745n 1.0v 639.755n 0.0v 644.745n 0.0v 644.755n 0.0v 649.745n 0.0v 649.755n 0.0v 654.745n 0.0v 654.755n 1.0v 659.745n 1.0v 659.755n 1.0v 664.745n 1.0v 664.755n 1.0v 669.745n 1.0v 669.755n 1.0v 674.745n 1.0v 674.755n 0.0v 679.745n 0.0v 679.755n 1.0v 684.745n 1.0v 684.755n 1.0v 689.745n 1.0v 689.755n 1.0v 694.745n 1.0v 694.755n 1.0v 699.745n 1.0v 699.755n 1.0v 704.745n 1.0v 704.755n 1.0v 709.745n 1.0v 709.755n 1.0v 714.745n 1.0v 714.755n 0.0v 719.745n 0.0v 719.755n 0.0v 724.745n 0.0v 724.755n 0.0v 729.745n 0.0v 729.755n 0.0v 734.745n 0.0v 734.755n 0.0v 739.745n 0.0v 739.755n 0.0v 744.745n 0.0v 744.755n 0.0v 749.745n 0.0v 749.755n 0.0v 754.745n 0.0v 754.755n 0.0v 759.745n 0.0v 759.755n 0.0v 764.745n 0.0v 764.755n 0.0v 769.745n 0.0v 769.755n 0.0v 774.745n 0.0v 774.755n 0.0v 779.745n 0.0v 779.755n 0.0v 784.745n 0.0v 784.755n 0.0v 789.745n 0.0v 789.755n 1.0v 794.745n 1.0v 794.755n 0.0v 799.745n 0.0v 799.755n 1.0v 804.745n 1.0v 804.755n 1.0v 809.745n 1.0v 809.755n 1.0v 814.745n 1.0v 814.755n 1.0v 819.745n 1.0v 819.755n 0.0v 824.745n 0.0v 824.755n 0.0v 829.745n 0.0v 829.755n 0.0v 834.745n 0.0v 834.755n 0.0v 839.745n 0.0v 839.755n 0.0v 844.745n 0.0v 844.755n 0.0v 849.745n 0.0v 849.755n 0.0v 854.745n 0.0v 854.755n 0.0v 859.745n 0.0v 859.755n 0.0v 864.745n 0.0v 864.755n 0.0v 869.745n 0.0v 869.755n 0.0v 874.745n 0.0v 874.755n 0.0v 879.745n 0.0v 879.755n 0.0v 884.745n 0.0v 884.755n 0.0v 889.745n 0.0v 889.755n 0.0v 894.745n 0.0v 894.755n 1.0v 899.745n 1.0v 899.755n 1.0v 904.745n 1.0v 904.755n 0.0v 909.745n 0.0v 909.755n 0.0v 914.745n 0.0v 914.755n 1.0v 919.745n 1.0v 919.755n 0.0v 924.745n 0.0v 924.755n 0.0v 929.745n 0.0v 929.755n 0.0v 934.745n 0.0v 934.755n 0.0v 939.745n 0.0v 939.755n 0.0v 944.745n 0.0v 944.755n 0.0v 949.745n 0.0v 949.755n 0.0v 954.745n 0.0v 954.755n 0.0v 959.745n 0.0v 959.755n 1.0v 964.745n 1.0v 964.755n 1.0v 969.745n 1.0v 969.755n 1.0v 974.745n 1.0v 974.755n 1.0v 979.745n 1.0v 979.755n 1.0v 984.745n 1.0v 984.755n 1.0v 989.745n 1.0v 989.755n 1.0v 994.745n 1.0v 994.755n 1.0v 999.745n 1.0v 999.755n 1.0v 1004.745n 1.0v 1004.755n 1.0v 1009.745n 1.0v 1009.755n 1.0v 1014.745n 1.0v 1014.755n 0.0v 1019.745n 0.0v 1019.755n 0.0v 1024.745n 0.0v 1024.755n 0.0v )
* (time, data): [(0, 0), (5, 1), (10, 0), (15, 1), (20, 1), (25, 1), (30, 1), (35, 1), (40, 1), (45, 1), (50, 1), (55, 1), (60, 0), (65, 0), (70, 0), (75, 1), (80, 1), (85, 1), (90, 1), (95, 1), (100, 1), (105, 1), (110, 1), (115, 1), (120, 0), (125, 0), (130, 0), (135, 0), (140, 0), (145, 0), (150, 0), (155, 0), (160, 0), (165, 0), (170, 0), (175, 0), (180, 0), (185, 0), (190, 0), (195, 0), (200, 1), (205, 0), (210, 0), (215, 0), (220, 0), (225, 0), (230, 0), (235, 0), (240, 0), (245, 0), (250, 0), (255, 0), (260, 0), (265, 0), (270, 0), (275, 1), (280, 1), (285, 0), (290, 0), (295, 0), (300, 0), (305, 0), (310, 0), (315, 0), (320, 0), (325, 0), (330, 0), (335, 0), (340, 0), (345, 0), (350, 0), (355, 0), (360, 0), (365, 0), (370, 0), (375, 0), (380, 0), (385, 0), (390, 0), (395, 0), (400, 0), (405, 0), (410, 0), (415, 0), (420, 0), (425, 0), (430, 0), (435, 0), (440, 0), (445, 1), (450, 0), (455, 0), (460, 0), (465, 0), (470, 0), (475, 1), (480, 1), (485, 1), (490, 1), (495, 1), (500, 1), (505, 1), (510, 1), (515, 1), (520, 1), (525, 1), (530, 1), (535, 1), (540, 1), (545, 1), (550, 1), (555, 1), (560, 1), (565, 1), (570, 1), (575, 1), (580, 1), (585, 1), (590, 1), (595, 0), (600, 0), (605, 0), (610, 0), (615, 0), (620, 0), (625, 0), (630, 1), (635, 1), (640, 1), (645, 1), (650, 1), (655, 1), (660, 1), (665, 1), (670, 1), (675, 1), (680, 0), (685, 0), (690, 0), (695, 1), (700, 1), (705, 1), (710, 1), (715, 0), (720, 0), (725, 0), (730, 0), (735, 0), (740, 0), (745, 0), (750, 1), (755, 1), (760, 1), (765, 1), (770, 1), (775, 0), (780, 0), (785, 0), (790, 1), (795, 1), (800, 1), (805, 1), (810, 1), (815, 1), (820, 0), (825, 0), (830, 0), (835, 0), (840, 0), (845, 0), (850, 0), (855, 0), (860, 0), (865, 0), (870, 0), (875, 0), (880, 0), (885, 0), (890, 0), (895, 0), (900, 0), (905, 0), (910, 0), (915, 0), (920, 1), (925, 1), (930, 1), (935, 1), (940, 1), (945, 1), (950, 1), (955, 1), (960, 1), (965, 1), (970, 1), (975, 1), (980, 1), (985, 1), (990, 1), (995, 1), (1000, 1), (1005, 1), (1010, 1), (1015, 1), (1020, 1), (1025, 1)]
Vdin0_6  din0_6  0 PWL (0n 0.0v 4.745n 0.0v 4.755n 1.0v 9.745n 1.0v 9.755n 0.0v 14.745n 0.0v 14.755n 1.0v 19.745n 1.0v 19.755n 1.0v 24.745n 1.0v 24.755n 1.0v 29.745n 1.0v 29.755n 1.0v 34.745n 1.0v 34.755n 1.0v 39.745n 1.0v 39.755n 1.0v 44.745n 1.0v 44.755n 1.0v 49.745n 1.0v 49.755n 1.0v 54.745n 1.0v 54.755n 1.0v 59.745n 1.0v 59.755n 0.0v 64.745n 0.0v 64.755n 0.0v 69.745n 0.0v 69.755n 0.0v 74.745n 0.0v 74.755n 1.0v 79.745n 1.0v 79.755n 1.0v 84.745n 1.0v 84.755n 1.0v 89.745n 1.0v 89.755n 1.0v 94.745n 1.0v 94.755n 1.0v 99.745n 1.0v 99.755n 1.0v 104.745n 1.0v 104.755n 1.0v 109.745n 1.0v 109.755n 1.0v 114.745n 1.0v 114.755n 1.0v 119.745n 1.0v 119.755n 0.0v 124.745n 0.0v 124.755n 0.0v 129.745n 0.0v 129.755n 0.0v 134.745n 0.0v 134.755n 0.0v 139.745n 0.0v 139.755n 0.0v 144.745n 0.0v 144.755n 0.0v 149.745n 0.0v 149.755n 0.0v 154.745n 0.0v 154.755n 0.0v 159.745n 0.0v 159.755n 0.0v 164.745n 0.0v 164.755n 0.0v 169.745n 0.0v 169.755n 0.0v 174.745n 0.0v 174.755n 0.0v 179.745n 0.0v 179.755n 0.0v 184.745n 0.0v 184.755n 0.0v 189.745n 0.0v 189.755n 0.0v 194.745n 0.0v 194.755n 0.0v 199.745n 0.0v 199.755n 1.0v 204.745n 1.0v 204.755n 0.0v 209.745n 0.0v 209.755n 0.0v 214.745n 0.0v 214.755n 0.0v 219.745n 0.0v 219.755n 0.0v 224.745n 0.0v 224.755n 0.0v 229.745n 0.0v 229.755n 0.0v 234.745n 0.0v 234.755n 0.0v 239.745n 0.0v 239.755n 0.0v 244.745n 0.0v 244.755n 0.0v 249.745n 0.0v 249.755n 0.0v 254.745n 0.0v 254.755n 0.0v 259.745n 0.0v 259.755n 0.0v 264.745n 0.0v 264.755n 0.0v 269.745n 0.0v 269.755n 0.0v 274.745n 0.0v 274.755n 1.0v 279.745n 1.0v 279.755n 1.0v 284.745n 1.0v 284.755n 0.0v 289.745n 0.0v 289.755n 0.0v 294.745n 0.0v 294.755n 0.0v 299.745n 0.0v 299.755n 0.0v 304.745n 0.0v 304.755n 0.0v 309.745n 0.0v 309.755n 0.0v 314.745n 0.0v 314.755n 0.0v 319.745n 0.0v 319.755n 0.0v 324.745n 0.0v 324.755n 0.0v 329.745n 0.0v 329.755n 0.0v 334.745n 0.0v 334.755n 0.0v 339.745n 0.0v 339.755n 0.0v 344.745n 0.0v 344.755n 0.0v 349.745n 0.0v 349.755n 0.0v 354.745n 0.0v 354.755n 0.0v 359.745n 0.0v 359.755n 0.0v 364.745n 0.0v 364.755n 0.0v 369.745n 0.0v 369.755n 0.0v 374.745n 0.0v 374.755n 0.0v 379.745n 0.0v 379.755n 0.0v 384.745n 0.0v 384.755n 0.0v 389.745n 0.0v 389.755n 0.0v 394.745n 0.0v 394.755n 0.0v 399.745n 0.0v 399.755n 0.0v 404.745n 0.0v 404.755n 0.0v 409.745n 0.0v 409.755n 0.0v 414.745n 0.0v 414.755n 0.0v 419.745n 0.0v 419.755n 0.0v 424.745n 0.0v 424.755n 0.0v 429.745n 0.0v 429.755n 0.0v 434.745n 0.0v 434.755n 0.0v 439.745n 0.0v 439.755n 0.0v 444.745n 0.0v 444.755n 1.0v 449.745n 1.0v 449.755n 0.0v 454.745n 0.0v 454.755n 0.0v 459.745n 0.0v 459.755n 0.0v 464.745n 0.0v 464.755n 0.0v 469.745n 0.0v 469.755n 0.0v 474.745n 0.0v 474.755n 1.0v 479.745n 1.0v 479.755n 1.0v 484.745n 1.0v 484.755n 1.0v 489.745n 1.0v 489.755n 1.0v 494.745n 1.0v 494.755n 1.0v 499.745n 1.0v 499.755n 1.0v 504.745n 1.0v 504.755n 1.0v 509.745n 1.0v 509.755n 1.0v 514.745n 1.0v 514.755n 1.0v 519.745n 1.0v 519.755n 1.0v 524.745n 1.0v 524.755n 1.0v 529.745n 1.0v 529.755n 1.0v 534.745n 1.0v 534.755n 1.0v 539.745n 1.0v 539.755n 1.0v 544.745n 1.0v 544.755n 1.0v 549.745n 1.0v 549.755n 1.0v 554.745n 1.0v 554.755n 1.0v 559.745n 1.0v 559.755n 1.0v 564.745n 1.0v 564.755n 1.0v 569.745n 1.0v 569.755n 1.0v 574.745n 1.0v 574.755n 1.0v 579.745n 1.0v 579.755n 1.0v 584.745n 1.0v 584.755n 1.0v 589.745n 1.0v 589.755n 1.0v 594.745n 1.0v 594.755n 0.0v 599.745n 0.0v 599.755n 0.0v 604.745n 0.0v 604.755n 0.0v 609.745n 0.0v 609.755n 0.0v 614.745n 0.0v 614.755n 0.0v 619.745n 0.0v 619.755n 0.0v 624.745n 0.0v 624.755n 0.0v 629.745n 0.0v 629.755n 1.0v 634.745n 1.0v 634.755n 1.0v 639.745n 1.0v 639.755n 1.0v 644.745n 1.0v 644.755n 1.0v 649.745n 1.0v 649.755n 1.0v 654.745n 1.0v 654.755n 1.0v 659.745n 1.0v 659.755n 1.0v 664.745n 1.0v 664.755n 1.0v 669.745n 1.0v 669.755n 1.0v 674.745n 1.0v 674.755n 1.0v 679.745n 1.0v 679.755n 0.0v 684.745n 0.0v 684.755n 0.0v 689.745n 0.0v 689.755n 0.0v 694.745n 0.0v 694.755n 1.0v 699.745n 1.0v 699.755n 1.0v 704.745n 1.0v 704.755n 1.0v 709.745n 1.0v 709.755n 1.0v 714.745n 1.0v 714.755n 0.0v 719.745n 0.0v 719.755n 0.0v 724.745n 0.0v 724.755n 0.0v 729.745n 0.0v 729.755n 0.0v 734.745n 0.0v 734.755n 0.0v 739.745n 0.0v 739.755n 0.0v 744.745n 0.0v 744.755n 0.0v 749.745n 0.0v 749.755n 1.0v 754.745n 1.0v 754.755n 1.0v 759.745n 1.0v 759.755n 1.0v 764.745n 1.0v 764.755n 1.0v 769.745n 1.0v 769.755n 1.0v 774.745n 1.0v 774.755n 0.0v 779.745n 0.0v 779.755n 0.0v 784.745n 0.0v 784.755n 0.0v 789.745n 0.0v 789.755n 1.0v 794.745n 1.0v 794.755n 1.0v 799.745n 1.0v 799.755n 1.0v 804.745n 1.0v 804.755n 1.0v 809.745n 1.0v 809.755n 1.0v 814.745n 1.0v 814.755n 1.0v 819.745n 1.0v 819.755n 0.0v 824.745n 0.0v 824.755n 0.0v 829.745n 0.0v 829.755n 0.0v 834.745n 0.0v 834.755n 0.0v 839.745n 0.0v 839.755n 0.0v 844.745n 0.0v 844.755n 0.0v 849.745n 0.0v 849.755n 0.0v 854.745n 0.0v 854.755n 0.0v 859.745n 0.0v 859.755n 0.0v 864.745n 0.0v 864.755n 0.0v 869.745n 0.0v 869.755n 0.0v 874.745n 0.0v 874.755n 0.0v 879.745n 0.0v 879.755n 0.0v 884.745n 0.0v 884.755n 0.0v 889.745n 0.0v 889.755n 0.0v 894.745n 0.0v 894.755n 0.0v 899.745n 0.0v 899.755n 0.0v 904.745n 0.0v 904.755n 0.0v 909.745n 0.0v 909.755n 0.0v 914.745n 0.0v 914.755n 0.0v 919.745n 0.0v 919.755n 1.0v 924.745n 1.0v 924.755n 1.0v 929.745n 1.0v 929.755n 1.0v 934.745n 1.0v 934.755n 1.0v 939.745n 1.0v 939.755n 1.0v 944.745n 1.0v 944.755n 1.0v 949.745n 1.0v 949.755n 1.0v 954.745n 1.0v 954.755n 1.0v 959.745n 1.0v 959.755n 1.0v 964.745n 1.0v 964.755n 1.0v 969.745n 1.0v 969.755n 1.0v 974.745n 1.0v 974.755n 1.0v 979.745n 1.0v 979.755n 1.0v 984.745n 1.0v 984.755n 1.0v 989.745n 1.0v 989.755n 1.0v 994.745n 1.0v 994.755n 1.0v 999.745n 1.0v 999.755n 1.0v 1004.745n 1.0v 1004.755n 1.0v 1009.745n 1.0v 1009.755n 1.0v 1014.745n 1.0v 1014.755n 1.0v 1019.745n 1.0v 1019.755n 1.0v 1024.745n 1.0v 1024.755n 1.0v )
* (time, data): [(0, 0), (5, 0), (10, 1), (15, 0), (20, 0), (25, 0), (30, 0), (35, 0), (40, 0), (45, 0), (50, 0), (55, 0), (60, 0), (65, 0), (70, 1), (75, 1), (80, 1), (85, 1), (90, 1), (95, 0), (100, 0), (105, 0), (110, 0), (115, 0), (120, 1), (125, 1), (130, 1), (135, 0), (140, 0), (145, 0), (150, 0), (155, 0), (160, 0), (165, 0), (170, 0), (175, 0), (180, 0), (185, 0), (190, 0), (195, 0), (200, 0), (205, 1), (210, 1), (215, 1), (220, 1), (225, 1), (230, 1), (235, 1), (240, 1), (245, 1), (250, 1), (255, 1), (260, 0), (265, 0), (270, 0), (275, 1), (280, 1), (285, 0), (290, 0), (295, 0), (300, 0), (305, 0), (310, 0), (315, 0), (320, 1), (325, 1), (330, 1), (335, 1), (340, 1), (345, 1), (350, 0), (355, 0), (360, 0), (365, 0), (370, 0), (375, 0), (380, 0), (385, 0), (390, 0), (395, 0), (400, 0), (405, 0), (410, 1), (415, 1), (420, 1), (425, 1), (430, 1), (435, 1), (440, 1), (445, 1), (450, 1), (455, 0), (460, 0), (465, 0), (470, 0), (475, 0), (480, 0), (485, 0), (490, 0), (495, 0), (500, 0), (505, 0), (510, 0), (515, 0), (520, 1), (525, 1), (530, 1), (535, 1), (540, 1), (545, 1), (550, 1), (555, 1), (560, 1), (565, 1), (570, 1), (575, 1), (580, 1), (585, 1), (590, 1), (595, 1), (600, 1), (605, 1), (610, 1), (615, 1), (620, 1), (625, 0), (630, 1), (635, 1), (640, 0), (645, 0), (650, 0), (655, 0), (660, 0), (665, 0), (670, 0), (675, 1), (680, 1), (685, 1), (690, 1), (695, 0), (700, 0), (705, 0), (710, 0), (715, 1), (720, 1), (725, 1), (730, 1), (735, 1), (740, 1), (745, 1), (750, 0), (755, 0), (760, 0), (765, 0), (770, 0), (775, 1), (780, 1), (785, 1), (790, 1), (795, 1), (800, 0), (805, 0), (810, 0), (815, 0), (820, 0), (825, 0), (830, 0), (835, 0), (840, 0), (845, 0), (850, 0), (855, 0), (860, 0), (865, 0), (870, 0), (875, 0), (880, 0), (885, 0), (890, 0), (895, 0), (900, 0), (905, 1), (910, 1), (915, 1), (920, 1), (925, 1), (930, 0), (935, 0), (940, 0), (945, 0), (950, 0), (955, 0), (960, 0), (965, 0), (970, 0), (975, 0), (980, 0), (985, 0), (990, 0), (995, 0), (1000, 0), (1005, 0), (1010, 0), (1015, 1), (1020, 1), (1025, 1)]
Vdin0_7  din0_7  0 PWL (0n 0.0v 4.745n 0.0v 4.755n 0.0v 9.745n 0.0v 9.755n 1.0v 14.745n 1.0v 14.755n 0.0v 19.745n 0.0v 19.755n 0.0v 24.745n 0.0v 24.755n 0.0v 29.745n 0.0v 29.755n 0.0v 34.745n 0.0v 34.755n 0.0v 39.745n 0.0v 39.755n 0.0v 44.745n 0.0v 44.755n 0.0v 49.745n 0.0v 49.755n 0.0v 54.745n 0.0v 54.755n 0.0v 59.745n 0.0v 59.755n 0.0v 64.745n 0.0v 64.755n 0.0v 69.745n 0.0v 69.755n 1.0v 74.745n 1.0v 74.755n 1.0v 79.745n 1.0v 79.755n 1.0v 84.745n 1.0v 84.755n 1.0v 89.745n 1.0v 89.755n 1.0v 94.745n 1.0v 94.755n 0.0v 99.745n 0.0v 99.755n 0.0v 104.745n 0.0v 104.755n 0.0v 109.745n 0.0v 109.755n 0.0v 114.745n 0.0v 114.755n 0.0v 119.745n 0.0v 119.755n 1.0v 124.745n 1.0v 124.755n 1.0v 129.745n 1.0v 129.755n 1.0v 134.745n 1.0v 134.755n 0.0v 139.745n 0.0v 139.755n 0.0v 144.745n 0.0v 144.755n 0.0v 149.745n 0.0v 149.755n 0.0v 154.745n 0.0v 154.755n 0.0v 159.745n 0.0v 159.755n 0.0v 164.745n 0.0v 164.755n 0.0v 169.745n 0.0v 169.755n 0.0v 174.745n 0.0v 174.755n 0.0v 179.745n 0.0v 179.755n 0.0v 184.745n 0.0v 184.755n 0.0v 189.745n 0.0v 189.755n 0.0v 194.745n 0.0v 194.755n 0.0v 199.745n 0.0v 199.755n 0.0v 204.745n 0.0v 204.755n 1.0v 209.745n 1.0v 209.755n 1.0v 214.745n 1.0v 214.755n 1.0v 219.745n 1.0v 219.755n 1.0v 224.745n 1.0v 224.755n 1.0v 229.745n 1.0v 229.755n 1.0v 234.745n 1.0v 234.755n 1.0v 239.745n 1.0v 239.755n 1.0v 244.745n 1.0v 244.755n 1.0v 249.745n 1.0v 249.755n 1.0v 254.745n 1.0v 254.755n 1.0v 259.745n 1.0v 259.755n 0.0v 264.745n 0.0v 264.755n 0.0v 269.745n 0.0v 269.755n 0.0v 274.745n 0.0v 274.755n 1.0v 279.745n 1.0v 279.755n 1.0v 284.745n 1.0v 284.755n 0.0v 289.745n 0.0v 289.755n 0.0v 294.745n 0.0v 294.755n 0.0v 299.745n 0.0v 299.755n 0.0v 304.745n 0.0v 304.755n 0.0v 309.745n 0.0v 309.755n 0.0v 314.745n 0.0v 314.755n 0.0v 319.745n 0.0v 319.755n 1.0v 324.745n 1.0v 324.755n 1.0v 329.745n 1.0v 329.755n 1.0v 334.745n 1.0v 334.755n 1.0v 339.745n 1.0v 339.755n 1.0v 344.745n 1.0v 344.755n 1.0v 349.745n 1.0v 349.755n 0.0v 354.745n 0.0v 354.755n 0.0v 359.745n 0.0v 359.755n 0.0v 364.745n 0.0v 364.755n 0.0v 369.745n 0.0v 369.755n 0.0v 374.745n 0.0v 374.755n 0.0v 379.745n 0.0v 379.755n 0.0v 384.745n 0.0v 384.755n 0.0v 389.745n 0.0v 389.755n 0.0v 394.745n 0.0v 394.755n 0.0v 399.745n 0.0v 399.755n 0.0v 404.745n 0.0v 404.755n 0.0v 409.745n 0.0v 409.755n 1.0v 414.745n 1.0v 414.755n 1.0v 419.745n 1.0v 419.755n 1.0v 424.745n 1.0v 424.755n 1.0v 429.745n 1.0v 429.755n 1.0v 434.745n 1.0v 434.755n 1.0v 439.745n 1.0v 439.755n 1.0v 444.745n 1.0v 444.755n 1.0v 449.745n 1.0v 449.755n 1.0v 454.745n 1.0v 454.755n 0.0v 459.745n 0.0v 459.755n 0.0v 464.745n 0.0v 464.755n 0.0v 469.745n 0.0v 469.755n 0.0v 474.745n 0.0v 474.755n 0.0v 479.745n 0.0v 479.755n 0.0v 484.745n 0.0v 484.755n 0.0v 489.745n 0.0v 489.755n 0.0v 494.745n 0.0v 494.755n 0.0v 499.745n 0.0v 499.755n 0.0v 504.745n 0.0v 504.755n 0.0v 509.745n 0.0v 509.755n 0.0v 514.745n 0.0v 514.755n 0.0v 519.745n 0.0v 519.755n 1.0v 524.745n 1.0v 524.755n 1.0v 529.745n 1.0v 529.755n 1.0v 534.745n 1.0v 534.755n 1.0v 539.745n 1.0v 539.755n 1.0v 544.745n 1.0v 544.755n 1.0v 549.745n 1.0v 549.755n 1.0v 554.745n 1.0v 554.755n 1.0v 559.745n 1.0v 559.755n 1.0v 564.745n 1.0v 564.755n 1.0v 569.745n 1.0v 569.755n 1.0v 574.745n 1.0v 574.755n 1.0v 579.745n 1.0v 579.755n 1.0v 584.745n 1.0v 584.755n 1.0v 589.745n 1.0v 589.755n 1.0v 594.745n 1.0v 594.755n 1.0v 599.745n 1.0v 599.755n 1.0v 604.745n 1.0v 604.755n 1.0v 609.745n 1.0v 609.755n 1.0v 614.745n 1.0v 614.755n 1.0v 619.745n 1.0v 619.755n 1.0v 624.745n 1.0v 624.755n 0.0v 629.745n 0.0v 629.755n 1.0v 634.745n 1.0v 634.755n 1.0v 639.745n 1.0v 639.755n 0.0v 644.745n 0.0v 644.755n 0.0v 649.745n 0.0v 649.755n 0.0v 654.745n 0.0v 654.755n 0.0v 659.745n 0.0v 659.755n 0.0v 664.745n 0.0v 664.755n 0.0v 669.745n 0.0v 669.755n 0.0v 674.745n 0.0v 674.755n 1.0v 679.745n 1.0v 679.755n 1.0v 684.745n 1.0v 684.755n 1.0v 689.745n 1.0v 689.755n 1.0v 694.745n 1.0v 694.755n 0.0v 699.745n 0.0v 699.755n 0.0v 704.745n 0.0v 704.755n 0.0v 709.745n 0.0v 709.755n 0.0v 714.745n 0.0v 714.755n 1.0v 719.745n 1.0v 719.755n 1.0v 724.745n 1.0v 724.755n 1.0v 729.745n 1.0v 729.755n 1.0v 734.745n 1.0v 734.755n 1.0v 739.745n 1.0v 739.755n 1.0v 744.745n 1.0v 744.755n 1.0v 749.745n 1.0v 749.755n 0.0v 754.745n 0.0v 754.755n 0.0v 759.745n 0.0v 759.755n 0.0v 764.745n 0.0v 764.755n 0.0v 769.745n 0.0v 769.755n 0.0v 774.745n 0.0v 774.755n 1.0v 779.745n 1.0v 779.755n 1.0v 784.745n 1.0v 784.755n 1.0v 789.745n 1.0v 789.755n 1.0v 794.745n 1.0v 794.755n 1.0v 799.745n 1.0v 799.755n 0.0v 804.745n 0.0v 804.755n 0.0v 809.745n 0.0v 809.755n 0.0v 814.745n 0.0v 814.755n 0.0v 819.745n 0.0v 819.755n 0.0v 824.745n 0.0v 824.755n 0.0v 829.745n 0.0v 829.755n 0.0v 834.745n 0.0v 834.755n 0.0v 839.745n 0.0v 839.755n 0.0v 844.745n 0.0v 844.755n 0.0v 849.745n 0.0v 849.755n 0.0v 854.745n 0.0v 854.755n 0.0v 859.745n 0.0v 859.755n 0.0v 864.745n 0.0v 864.755n 0.0v 869.745n 0.0v 869.755n 0.0v 874.745n 0.0v 874.755n 0.0v 879.745n 0.0v 879.755n 0.0v 884.745n 0.0v 884.755n 0.0v 889.745n 0.0v 889.755n 0.0v 894.745n 0.0v 894.755n 0.0v 899.745n 0.0v 899.755n 0.0v 904.745n 0.0v 904.755n 1.0v 909.745n 1.0v 909.755n 1.0v 914.745n 1.0v 914.755n 1.0v 919.745n 1.0v 919.755n 1.0v 924.745n 1.0v 924.755n 1.0v 929.745n 1.0v 929.755n 0.0v 934.745n 0.0v 934.755n 0.0v 939.745n 0.0v 939.755n 0.0v 944.745n 0.0v 944.755n 0.0v 949.745n 0.0v 949.755n 0.0v 954.745n 0.0v 954.755n 0.0v 959.745n 0.0v 959.755n 0.0v 964.745n 0.0v 964.755n 0.0v 969.745n 0.0v 969.755n 0.0v 974.745n 0.0v 974.755n 0.0v 979.745n 0.0v 979.755n 0.0v 984.745n 0.0v 984.755n 0.0v 989.745n 0.0v 989.755n 0.0v 994.745n 0.0v 994.755n 0.0v 999.745n 0.0v 999.755n 0.0v 1004.745n 0.0v 1004.755n 0.0v 1009.745n 0.0v 1009.755n 0.0v 1014.745n 0.0v 1014.755n 1.0v 1019.745n 1.0v 1019.755n 1.0v 1024.745n 1.0v 1024.755n 1.0v )
* (time, data): [(0, 0), (5, 1), (10, 1), (15, 0), (20, 1), (25, 1), (30, 1), (35, 1), (40, 0), (45, 0), (50, 0), (55, 0), (60, 1), (65, 1), (70, 0), (75, 0), (80, 0), (85, 1), (90, 1), (95, 1), (100, 0), (105, 1), (110, 1), (115, 1), (120, 1), (125, 0), (130, 0), (135, 0), (140, 0), (145, 0), (150, 0), (155, 0), (160, 0), (165, 1), (170, 1), (175, 1), (180, 1), (185, 1), (190, 1), (195, 1), (200, 1), (205, 1), (210, 1), (215, 1), (220, 0), (225, 0), (230, 0), (235, 0), (240, 0), (245, 0), (250, 0), (255, 1), (260, 1), (265, 1), (270, 1), (275, 1), (280, 1), (285, 1), (290, 1), (295, 0), (300, 0), (305, 1), (310, 1), (315, 1), (320, 0), (325, 0), (330, 0), (335, 0), (340, 1), (345, 1), (350, 1), (355, 1), (360, 1), (365, 1), (370, 0), (375, 0), (380, 0), (385, 1), (390, 1), (395, 0), (400, 0), (405, 1), (410, 1), (415, 1), (420, 0), (425, 1), (430, 1), (435, 0), (440, 0), (445, 0), (450, 1), (455, 0), (460, 1), (465, 1), (470, 1), (475, 0), (480, 1), (485, 1), (490, 1), (495, 0), (500, 0), (505, 1), (510, 1), (515, 1), (520, 0), (525, 1), (530, 1), (535, 1), (540, 1), (545, 0), (550, 1), (555, 1), (560, 1), (565, 1), (570, 0), (575, 1), (580, 1), (585, 0), (590, 0), (595, 1), (600, 1), (605, 1), (610, 1), (615, 0), (620, 0), (625, 0), (630, 1), (635, 0), (640, 1), (645, 1), (650, 1), (655, 0), (660, 1), (665, 0), (670, 0), (675, 1), (680, 1), (685, 0), (690, 0), (695, 0), (700, 1), (705, 1), (710, 1), (715, 1), (720, 0), (725, 1), (730, 0), (735, 0), (740, 0), (745, 0), (750, 0), (755, 0), (760, 0), (765, 0), (770, 0), (775, 1), (780, 1), (785, 0), (790, 0), (795, 0), (800, 1), (805, 1), (810, 1), (815, 0), (820, 0), (825, 0), (830, 0), (835, 0), (840, 0), (845, 1), (850, 1), (855, 0), (860, 0), (865, 1), (870, 1), (875, 0), (880, 1), (885, 1), (890, 1), (895, 1), (900, 1), (905, 0), (910, 1), (915, 1), (920, 1), (925, 1), (930, 1), (935, 1), (940, 1), (945, 1), (950, 1), (955, 1), (960, 0), (965, 0), (970, 1), (975, 1), (980, 1), (985, 1), (990, 1), (995, 1), (1000, 1), (1005, 1), (1010, 1), (1015, 1), (1020, 1), (1025, 1)]
Va0_0  a0_0  0 PWL (0n 0.0v 4.745n 0.0v 4.755n 1.0v 9.745n 1.0v 9.755n 1.0v 14.745n 1.0v 14.755n 0.0v 19.745n 0.0v 19.755n 1.0v 24.745n 1.0v 24.755n 1.0v 29.745n 1.0v 29.755n 1.0v 34.745n 1.0v 34.755n 1.0v 39.745n 1.0v 39.755n 0.0v 44.745n 0.0v 44.755n 0.0v 49.745n 0.0v 49.755n 0.0v 54.745n 0.0v 54.755n 0.0v 59.745n 0.0v 59.755n 1.0v 64.745n 1.0v 64.755n 1.0v 69.745n 1.0v 69.755n 0.0v 74.745n 0.0v 74.755n 0.0v 79.745n 0.0v 79.755n 0.0v 84.745n 0.0v 84.755n 1.0v 89.745n 1.0v 89.755n 1.0v 94.745n 1.0v 94.755n 1.0v 99.745n 1.0v 99.755n 0.0v 104.745n 0.0v 104.755n 1.0v 109.745n 1.0v 109.755n 1.0v 114.745n 1.0v 114.755n 1.0v 119.745n 1.0v 119.755n 1.0v 124.745n 1.0v 124.755n 0.0v 129.745n 0.0v 129.755n 0.0v 134.745n 0.0v 134.755n 0.0v 139.745n 0.0v 139.755n 0.0v 144.745n 0.0v 144.755n 0.0v 149.745n 0.0v 149.755n 0.0v 154.745n 0.0v 154.755n 0.0v 159.745n 0.0v 159.755n 0.0v 164.745n 0.0v 164.755n 1.0v 169.745n 1.0v 169.755n 1.0v 174.745n 1.0v 174.755n 1.0v 179.745n 1.0v 179.755n 1.0v 184.745n 1.0v 184.755n 1.0v 189.745n 1.0v 189.755n 1.0v 194.745n 1.0v 194.755n 1.0v 199.745n 1.0v 199.755n 1.0v 204.745n 1.0v 204.755n 1.0v 209.745n 1.0v 209.755n 1.0v 214.745n 1.0v 214.755n 1.0v 219.745n 1.0v 219.755n 0.0v 224.745n 0.0v 224.755n 0.0v 229.745n 0.0v 229.755n 0.0v 234.745n 0.0v 234.755n 0.0v 239.745n 0.0v 239.755n 0.0v 244.745n 0.0v 244.755n 0.0v 249.745n 0.0v 249.755n 0.0v 254.745n 0.0v 254.755n 1.0v 259.745n 1.0v 259.755n 1.0v 264.745n 1.0v 264.755n 1.0v 269.745n 1.0v 269.755n 1.0v 274.745n 1.0v 274.755n 1.0v 279.745n 1.0v 279.755n 1.0v 284.745n 1.0v 284.755n 1.0v 289.745n 1.0v 289.755n 1.0v 294.745n 1.0v 294.755n 0.0v 299.745n 0.0v 299.755n 0.0v 304.745n 0.0v 304.755n 1.0v 309.745n 1.0v 309.755n 1.0v 314.745n 1.0v 314.755n 1.0v 319.745n 1.0v 319.755n 0.0v 324.745n 0.0v 324.755n 0.0v 329.745n 0.0v 329.755n 0.0v 334.745n 0.0v 334.755n 0.0v 339.745n 0.0v 339.755n 1.0v 344.745n 1.0v 344.755n 1.0v 349.745n 1.0v 349.755n 1.0v 354.745n 1.0v 354.755n 1.0v 359.745n 1.0v 359.755n 1.0v 364.745n 1.0v 364.755n 1.0v 369.745n 1.0v 369.755n 0.0v 374.745n 0.0v 374.755n 0.0v 379.745n 0.0v 379.755n 0.0v 384.745n 0.0v 384.755n 1.0v 389.745n 1.0v 389.755n 1.0v 394.745n 1.0v 394.755n 0.0v 399.745n 0.0v 399.755n 0.0v 404.745n 0.0v 404.755n 1.0v 409.745n 1.0v 409.755n 1.0v 414.745n 1.0v 414.755n 1.0v 419.745n 1.0v 419.755n 0.0v 424.745n 0.0v 424.755n 1.0v 429.745n 1.0v 429.755n 1.0v 434.745n 1.0v 434.755n 0.0v 439.745n 0.0v 439.755n 0.0v 444.745n 0.0v 444.755n 0.0v 449.745n 0.0v 449.755n 1.0v 454.745n 1.0v 454.755n 0.0v 459.745n 0.0v 459.755n 1.0v 464.745n 1.0v 464.755n 1.0v 469.745n 1.0v 469.755n 1.0v 474.745n 1.0v 474.755n 0.0v 479.745n 0.0v 479.755n 1.0v 484.745n 1.0v 484.755n 1.0v 489.745n 1.0v 489.755n 1.0v 494.745n 1.0v 494.755n 0.0v 499.745n 0.0v 499.755n 0.0v 504.745n 0.0v 504.755n 1.0v 509.745n 1.0v 509.755n 1.0v 514.745n 1.0v 514.755n 1.0v 519.745n 1.0v 519.755n 0.0v 524.745n 0.0v 524.755n 1.0v 529.745n 1.0v 529.755n 1.0v 534.745n 1.0v 534.755n 1.0v 539.745n 1.0v 539.755n 1.0v 544.745n 1.0v 544.755n 0.0v 549.745n 0.0v 549.755n 1.0v 554.745n 1.0v 554.755n 1.0v 559.745n 1.0v 559.755n 1.0v 564.745n 1.0v 564.755n 1.0v 569.745n 1.0v 569.755n 0.0v 574.745n 0.0v 574.755n 1.0v 579.745n 1.0v 579.755n 1.0v 584.745n 1.0v 584.755n 0.0v 589.745n 0.0v 589.755n 0.0v 594.745n 0.0v 594.755n 1.0v 599.745n 1.0v 599.755n 1.0v 604.745n 1.0v 604.755n 1.0v 609.745n 1.0v 609.755n 1.0v 614.745n 1.0v 614.755n 0.0v 619.745n 0.0v 619.755n 0.0v 624.745n 0.0v 624.755n 0.0v 629.745n 0.0v 629.755n 1.0v 634.745n 1.0v 634.755n 0.0v 639.745n 0.0v 639.755n 1.0v 644.745n 1.0v 644.755n 1.0v 649.745n 1.0v 649.755n 1.0v 654.745n 1.0v 654.755n 0.0v 659.745n 0.0v 659.755n 1.0v 664.745n 1.0v 664.755n 0.0v 669.745n 0.0v 669.755n 0.0v 674.745n 0.0v 674.755n 1.0v 679.745n 1.0v 679.755n 1.0v 684.745n 1.0v 684.755n 0.0v 689.745n 0.0v 689.755n 0.0v 694.745n 0.0v 694.755n 0.0v 699.745n 0.0v 699.755n 1.0v 704.745n 1.0v 704.755n 1.0v 709.745n 1.0v 709.755n 1.0v 714.745n 1.0v 714.755n 1.0v 719.745n 1.0v 719.755n 0.0v 724.745n 0.0v 724.755n 1.0v 729.745n 1.0v 729.755n 0.0v 734.745n 0.0v 734.755n 0.0v 739.745n 0.0v 739.755n 0.0v 744.745n 0.0v 744.755n 0.0v 749.745n 0.0v 749.755n 0.0v 754.745n 0.0v 754.755n 0.0v 759.745n 0.0v 759.755n 0.0v 764.745n 0.0v 764.755n 0.0v 769.745n 0.0v 769.755n 0.0v 774.745n 0.0v 774.755n 1.0v 779.745n 1.0v 779.755n 1.0v 784.745n 1.0v 784.755n 0.0v 789.745n 0.0v 789.755n 0.0v 794.745n 0.0v 794.755n 0.0v 799.745n 0.0v 799.755n 1.0v 804.745n 1.0v 804.755n 1.0v 809.745n 1.0v 809.755n 1.0v 814.745n 1.0v 814.755n 0.0v 819.745n 0.0v 819.755n 0.0v 824.745n 0.0v 824.755n 0.0v 829.745n 0.0v 829.755n 0.0v 834.745n 0.0v 834.755n 0.0v 839.745n 0.0v 839.755n 0.0v 844.745n 0.0v 844.755n 1.0v 849.745n 1.0v 849.755n 1.0v 854.745n 1.0v 854.755n 0.0v 859.745n 0.0v 859.755n 0.0v 864.745n 0.0v 864.755n 1.0v 869.745n 1.0v 869.755n 1.0v 874.745n 1.0v 874.755n 0.0v 879.745n 0.0v 879.755n 1.0v 884.745n 1.0v 884.755n 1.0v 889.745n 1.0v 889.755n 1.0v 894.745n 1.0v 894.755n 1.0v 899.745n 1.0v 899.755n 1.0v 904.745n 1.0v 904.755n 0.0v 909.745n 0.0v 909.755n 1.0v 914.745n 1.0v 914.755n 1.0v 919.745n 1.0v 919.755n 1.0v 924.745n 1.0v 924.755n 1.0v 929.745n 1.0v 929.755n 1.0v 934.745n 1.0v 934.755n 1.0v 939.745n 1.0v 939.755n 1.0v 944.745n 1.0v 944.755n 1.0v 949.745n 1.0v 949.755n 1.0v 954.745n 1.0v 954.755n 1.0v 959.745n 1.0v 959.755n 0.0v 964.745n 0.0v 964.755n 0.0v 969.745n 0.0v 969.755n 1.0v 974.745n 1.0v 974.755n 1.0v 979.745n 1.0v 979.755n 1.0v 984.745n 1.0v 984.755n 1.0v 989.745n 1.0v 989.755n 1.0v 994.745n 1.0v 994.755n 1.0v 999.745n 1.0v 999.755n 1.0v 1004.745n 1.0v 1004.755n 1.0v 1009.745n 1.0v 1009.755n 1.0v 1014.745n 1.0v 1014.755n 1.0v 1019.745n 1.0v 1019.755n 1.0v 1024.745n 1.0v 1024.755n 1.0v )
* (time, data): [(0, 0), (5, 1), (10, 0), (15, 1), (20, 1), (25, 1), (30, 1), (35, 0), (40, 1), (45, 1), (50, 1), (55, 0), (60, 1), (65, 1), (70, 0), (75, 1), (80, 1), (85, 1), (90, 1), (95, 0), (100, 1), (105, 1), (110, 1), (115, 0), (120, 0), (125, 1), (130, 0), (135, 1), (140, 1), (145, 1), (150, 1), (155, 1), (160, 1), (165, 0), (170, 0), (175, 1), (180, 1), (185, 1), (190, 1), (195, 1), (200, 0), (205, 0), (210, 0), (215, 1), (220, 1), (225, 1), (230, 1), (235, 1), (240, 0), (245, 1), (250, 1), (255, 0), (260, 0), (265, 0), (270, 0), (275, 1), (280, 1), (285, 1), (290, 1), (295, 1), (300, 0), (305, 1), (310, 0), (315, 1), (320, 0), (325, 0), (330, 0), (335, 0), (340, 0), (345, 1), (350, 0), (355, 0), (360, 0), (365, 1), (370, 1), (375, 1), (380, 1), (385, 1), (390, 1), (395, 1), (400, 1), (405, 1), (410, 0), (415, 0), (420, 1), (425, 1), (430, 1), (435, 1), (440, 0), (445, 0), (450, 0), (455, 0), (460, 1), (465, 1), (470, 0), (475, 0), (480, 0), (485, 1), (490, 1), (495, 1), (500, 1), (505, 0), (510, 0), (515, 1), (520, 0), (525, 1), (530, 1), (535, 1), (540, 1), (545, 0), (550, 0), (555, 0), (560, 1), (565, 1), (570, 0), (575, 1), (580, 1), (585, 0), (590, 0), (595, 0), (600, 0), (605, 1), (610, 0), (615, 1), (620, 1), (625, 0), (630, 1), (635, 1), (640, 0), (645, 1), (650, 1), (655, 1), (660, 1), (665, 1), (670, 1), (675, 1), (680, 1), (685, 1), (690, 1), (695, 1), (700, 0), (705, 0), (710, 1), (715, 1), (720, 1), (725, 1), (730, 1), (735, 1), (740, 1), (745, 1), (750, 0), (755, 0), (760, 1), (765, 0), (770, 0), (775, 1), (780, 0), (785, 1), (790, 0), (795, 1), (800, 0), (805, 0), (810, 0), (815, 0), (820, 0), (825, 0), (830, 0), (835, 1), (840, 1), (845, 0), (850, 0), (855, 1), (860, 0), (865, 0), (870, 0), (875, 0), (880, 0), (885, 0), (890, 0), (895, 0), (900, 0), (905, 0), (910, 1), (915, 1), (920, 1), (925, 1), (930, 1), (935, 1), (940, 1), (945, 1), (950, 1), (955, 0), (960, 1), (965, 0), (970, 1), (975, 0), (980, 1), (985, 1), (990, 1), (995, 1), (1000, 1), (1005, 1), (1010, 1), (1015, 1), (1020, 1), (1025, 1)]
Va0_1  a0_1  0 PWL (0n 0.0v 4.745n 0.0v 4.755n 1.0v 9.745n 1.0v 9.755n 0.0v 14.745n 0.0v 14.755n 1.0v 19.745n 1.0v 19.755n 1.0v 24.745n 1.0v 24.755n 1.0v 29.745n 1.0v 29.755n 1.0v 34.745n 1.0v 34.755n 0.0v 39.745n 0.0v 39.755n 1.0v 44.745n 1.0v 44.755n 1.0v 49.745n 1.0v 49.755n 1.0v 54.745n 1.0v 54.755n 0.0v 59.745n 0.0v 59.755n 1.0v 64.745n 1.0v 64.755n 1.0v 69.745n 1.0v 69.755n 0.0v 74.745n 0.0v 74.755n 1.0v 79.745n 1.0v 79.755n 1.0v 84.745n 1.0v 84.755n 1.0v 89.745n 1.0v 89.755n 1.0v 94.745n 1.0v 94.755n 0.0v 99.745n 0.0v 99.755n 1.0v 104.745n 1.0v 104.755n 1.0v 109.745n 1.0v 109.755n 1.0v 114.745n 1.0v 114.755n 0.0v 119.745n 0.0v 119.755n 0.0v 124.745n 0.0v 124.755n 1.0v 129.745n 1.0v 129.755n 0.0v 134.745n 0.0v 134.755n 1.0v 139.745n 1.0v 139.755n 1.0v 144.745n 1.0v 144.755n 1.0v 149.745n 1.0v 149.755n 1.0v 154.745n 1.0v 154.755n 1.0v 159.745n 1.0v 159.755n 1.0v 164.745n 1.0v 164.755n 0.0v 169.745n 0.0v 169.755n 0.0v 174.745n 0.0v 174.755n 1.0v 179.745n 1.0v 179.755n 1.0v 184.745n 1.0v 184.755n 1.0v 189.745n 1.0v 189.755n 1.0v 194.745n 1.0v 194.755n 1.0v 199.745n 1.0v 199.755n 0.0v 204.745n 0.0v 204.755n 0.0v 209.745n 0.0v 209.755n 0.0v 214.745n 0.0v 214.755n 1.0v 219.745n 1.0v 219.755n 1.0v 224.745n 1.0v 224.755n 1.0v 229.745n 1.0v 229.755n 1.0v 234.745n 1.0v 234.755n 1.0v 239.745n 1.0v 239.755n 0.0v 244.745n 0.0v 244.755n 1.0v 249.745n 1.0v 249.755n 1.0v 254.745n 1.0v 254.755n 0.0v 259.745n 0.0v 259.755n 0.0v 264.745n 0.0v 264.755n 0.0v 269.745n 0.0v 269.755n 0.0v 274.745n 0.0v 274.755n 1.0v 279.745n 1.0v 279.755n 1.0v 284.745n 1.0v 284.755n 1.0v 289.745n 1.0v 289.755n 1.0v 294.745n 1.0v 294.755n 1.0v 299.745n 1.0v 299.755n 0.0v 304.745n 0.0v 304.755n 1.0v 309.745n 1.0v 309.755n 0.0v 314.745n 0.0v 314.755n 1.0v 319.745n 1.0v 319.755n 0.0v 324.745n 0.0v 324.755n 0.0v 329.745n 0.0v 329.755n 0.0v 334.745n 0.0v 334.755n 0.0v 339.745n 0.0v 339.755n 0.0v 344.745n 0.0v 344.755n 1.0v 349.745n 1.0v 349.755n 0.0v 354.745n 0.0v 354.755n 0.0v 359.745n 0.0v 359.755n 0.0v 364.745n 0.0v 364.755n 1.0v 369.745n 1.0v 369.755n 1.0v 374.745n 1.0v 374.755n 1.0v 379.745n 1.0v 379.755n 1.0v 384.745n 1.0v 384.755n 1.0v 389.745n 1.0v 389.755n 1.0v 394.745n 1.0v 394.755n 1.0v 399.745n 1.0v 399.755n 1.0v 404.745n 1.0v 404.755n 1.0v 409.745n 1.0v 409.755n 0.0v 414.745n 0.0v 414.755n 0.0v 419.745n 0.0v 419.755n 1.0v 424.745n 1.0v 424.755n 1.0v 429.745n 1.0v 429.755n 1.0v 434.745n 1.0v 434.755n 1.0v 439.745n 1.0v 439.755n 0.0v 444.745n 0.0v 444.755n 0.0v 449.745n 0.0v 449.755n 0.0v 454.745n 0.0v 454.755n 0.0v 459.745n 0.0v 459.755n 1.0v 464.745n 1.0v 464.755n 1.0v 469.745n 1.0v 469.755n 0.0v 474.745n 0.0v 474.755n 0.0v 479.745n 0.0v 479.755n 0.0v 484.745n 0.0v 484.755n 1.0v 489.745n 1.0v 489.755n 1.0v 494.745n 1.0v 494.755n 1.0v 499.745n 1.0v 499.755n 1.0v 504.745n 1.0v 504.755n 0.0v 509.745n 0.0v 509.755n 0.0v 514.745n 0.0v 514.755n 1.0v 519.745n 1.0v 519.755n 0.0v 524.745n 0.0v 524.755n 1.0v 529.745n 1.0v 529.755n 1.0v 534.745n 1.0v 534.755n 1.0v 539.745n 1.0v 539.755n 1.0v 544.745n 1.0v 544.755n 0.0v 549.745n 0.0v 549.755n 0.0v 554.745n 0.0v 554.755n 0.0v 559.745n 0.0v 559.755n 1.0v 564.745n 1.0v 564.755n 1.0v 569.745n 1.0v 569.755n 0.0v 574.745n 0.0v 574.755n 1.0v 579.745n 1.0v 579.755n 1.0v 584.745n 1.0v 584.755n 0.0v 589.745n 0.0v 589.755n 0.0v 594.745n 0.0v 594.755n 0.0v 599.745n 0.0v 599.755n 0.0v 604.745n 0.0v 604.755n 1.0v 609.745n 1.0v 609.755n 0.0v 614.745n 0.0v 614.755n 1.0v 619.745n 1.0v 619.755n 1.0v 624.745n 1.0v 624.755n 0.0v 629.745n 0.0v 629.755n 1.0v 634.745n 1.0v 634.755n 1.0v 639.745n 1.0v 639.755n 0.0v 644.745n 0.0v 644.755n 1.0v 649.745n 1.0v 649.755n 1.0v 654.745n 1.0v 654.755n 1.0v 659.745n 1.0v 659.755n 1.0v 664.745n 1.0v 664.755n 1.0v 669.745n 1.0v 669.755n 1.0v 674.745n 1.0v 674.755n 1.0v 679.745n 1.0v 679.755n 1.0v 684.745n 1.0v 684.755n 1.0v 689.745n 1.0v 689.755n 1.0v 694.745n 1.0v 694.755n 1.0v 699.745n 1.0v 699.755n 0.0v 704.745n 0.0v 704.755n 0.0v 709.745n 0.0v 709.755n 1.0v 714.745n 1.0v 714.755n 1.0v 719.745n 1.0v 719.755n 1.0v 724.745n 1.0v 724.755n 1.0v 729.745n 1.0v 729.755n 1.0v 734.745n 1.0v 734.755n 1.0v 739.745n 1.0v 739.755n 1.0v 744.745n 1.0v 744.755n 1.0v 749.745n 1.0v 749.755n 0.0v 754.745n 0.0v 754.755n 0.0v 759.745n 0.0v 759.755n 1.0v 764.745n 1.0v 764.755n 0.0v 769.745n 0.0v 769.755n 0.0v 774.745n 0.0v 774.755n 1.0v 779.745n 1.0v 779.755n 0.0v 784.745n 0.0v 784.755n 1.0v 789.745n 1.0v 789.755n 0.0v 794.745n 0.0v 794.755n 1.0v 799.745n 1.0v 799.755n 0.0v 804.745n 0.0v 804.755n 0.0v 809.745n 0.0v 809.755n 0.0v 814.745n 0.0v 814.755n 0.0v 819.745n 0.0v 819.755n 0.0v 824.745n 0.0v 824.755n 0.0v 829.745n 0.0v 829.755n 0.0v 834.745n 0.0v 834.755n 1.0v 839.745n 1.0v 839.755n 1.0v 844.745n 1.0v 844.755n 0.0v 849.745n 0.0v 849.755n 0.0v 854.745n 0.0v 854.755n 1.0v 859.745n 1.0v 859.755n 0.0v 864.745n 0.0v 864.755n 0.0v 869.745n 0.0v 869.755n 0.0v 874.745n 0.0v 874.755n 0.0v 879.745n 0.0v 879.755n 0.0v 884.745n 0.0v 884.755n 0.0v 889.745n 0.0v 889.755n 0.0v 894.745n 0.0v 894.755n 0.0v 899.745n 0.0v 899.755n 0.0v 904.745n 0.0v 904.755n 0.0v 909.745n 0.0v 909.755n 1.0v 914.745n 1.0v 914.755n 1.0v 919.745n 1.0v 919.755n 1.0v 924.745n 1.0v 924.755n 1.0v 929.745n 1.0v 929.755n 1.0v 934.745n 1.0v 934.755n 1.0v 939.745n 1.0v 939.755n 1.0v 944.745n 1.0v 944.755n 1.0v 949.745n 1.0v 949.755n 1.0v 954.745n 1.0v 954.755n 0.0v 959.745n 0.0v 959.755n 1.0v 964.745n 1.0v 964.755n 0.0v 969.745n 0.0v 969.755n 1.0v 974.745n 1.0v 974.755n 0.0v 979.745n 0.0v 979.755n 1.0v 984.745n 1.0v 984.755n 1.0v 989.745n 1.0v 989.755n 1.0v 994.745n 1.0v 994.755n 1.0v 999.745n 1.0v 999.755n 1.0v 1004.745n 1.0v 1004.755n 1.0v 1009.745n 1.0v 1009.755n 1.0v 1014.745n 1.0v 1014.755n 1.0v 1019.745n 1.0v 1019.755n 1.0v 1024.745n 1.0v 1024.755n 1.0v )
* (time, data): [(0, 0), (5, 1), (10, 0), (15, 0), (20, 1), (25, 1), (30, 1), (35, 0), (40, 0), (45, 0), (50, 0), (55, 0), (60, 1), (65, 1), (70, 0), (75, 1), (80, 1), (85, 1), (90, 1), (95, 1), (100, 0), (105, 1), (110, 1), (115, 1), (120, 0), (125, 0), (130, 0), (135, 0), (140, 1), (145, 0), (150, 0), (155, 0), (160, 0), (165, 0), (170, 0), (175, 1), (180, 1), (185, 1), (190, 1), (195, 1), (200, 0), (205, 1), (210, 0), (215, 1), (220, 0), (225, 0), (230, 1), (235, 1), (240, 0), (245, 1), (250, 1), (255, 0), (260, 1), (265, 1), (270, 1), (275, 0), (280, 1), (285, 0), (290, 0), (295, 0), (300, 0), (305, 1), (310, 1), (315, 0), (320, 0), (325, 0), (330, 0), (335, 0), (340, 1), (345, 0), (350, 0), (355, 0), (360, 0), (365, 0), (370, 1), (375, 1), (380, 0), (385, 0), (390, 1), (395, 0), (400, 0), (405, 1), (410, 0), (415, 0), (420, 1), (425, 1), (430, 0), (435, 0), (440, 0), (445, 1), (450, 0), (455, 1), (460, 0), (465, 0), (470, 1), (475, 1), (480, 0), (485, 0), (490, 0), (495, 1), (500, 0), (505, 1), (510, 1), (515, 0), (520, 0), (525, 0), (530, 0), (535, 1), (540, 1), (545, 1), (550, 1), (555, 1), (560, 1), (565, 1), (570, 0), (575, 1), (580, 1), (585, 0), (590, 0), (595, 0), (600, 0), (605, 0), (610, 1), (615, 0), (620, 0), (625, 1), (630, 0), (635, 1), (640, 0), (645, 1), (650, 1), (655, 0), (660, 1), (665, 1), (670, 1), (675, 0), (680, 1), (685, 0), (690, 0), (695, 1), (700, 1), (705, 1), (710, 0), (715, 1), (720, 0), (725, 1), (730, 0), (735, 0), (740, 0), (745, 0), (750, 1), (755, 1), (760, 0), (765, 1), (770, 1), (775, 0), (780, 0), (785, 0), (790, 1), (795, 1), (800, 0), (805, 1), (810, 1), (815, 1), (820, 1), (825, 1), (830, 1), (835, 1), (840, 1), (845, 0), (850, 0), (855, 0), (860, 0), (865, 0), (870, 0), (875, 1), (880, 0), (885, 0), (890, 0), (895, 1), (900, 1), (905, 0), (910, 0), (915, 0), (920, 1), (925, 1), (930, 1), (935, 0), (940, 0), (945, 0), (950, 0), (955, 1), (960, 1), (965, 0), (970, 1), (975, 0), (980, 1), (985, 1), (990, 1), (995, 0), (1000, 0), (1005, 0), (1010, 0), (1015, 1), (1020, 1), (1025, 1)]
Va0_2  a0_2  0 PWL (0n 0.0v 4.745n 0.0v 4.755n 1.0v 9.745n 1.0v 9.755n 0.0v 14.745n 0.0v 14.755n 0.0v 19.745n 0.0v 19.755n 1.0v 24.745n 1.0v 24.755n 1.0v 29.745n 1.0v 29.755n 1.0v 34.745n 1.0v 34.755n 0.0v 39.745n 0.0v 39.755n 0.0v 44.745n 0.0v 44.755n 0.0v 49.745n 0.0v 49.755n 0.0v 54.745n 0.0v 54.755n 0.0v 59.745n 0.0v 59.755n 1.0v 64.745n 1.0v 64.755n 1.0v 69.745n 1.0v 69.755n 0.0v 74.745n 0.0v 74.755n 1.0v 79.745n 1.0v 79.755n 1.0v 84.745n 1.0v 84.755n 1.0v 89.745n 1.0v 89.755n 1.0v 94.745n 1.0v 94.755n 1.0v 99.745n 1.0v 99.755n 0.0v 104.745n 0.0v 104.755n 1.0v 109.745n 1.0v 109.755n 1.0v 114.745n 1.0v 114.755n 1.0v 119.745n 1.0v 119.755n 0.0v 124.745n 0.0v 124.755n 0.0v 129.745n 0.0v 129.755n 0.0v 134.745n 0.0v 134.755n 0.0v 139.745n 0.0v 139.755n 1.0v 144.745n 1.0v 144.755n 0.0v 149.745n 0.0v 149.755n 0.0v 154.745n 0.0v 154.755n 0.0v 159.745n 0.0v 159.755n 0.0v 164.745n 0.0v 164.755n 0.0v 169.745n 0.0v 169.755n 0.0v 174.745n 0.0v 174.755n 1.0v 179.745n 1.0v 179.755n 1.0v 184.745n 1.0v 184.755n 1.0v 189.745n 1.0v 189.755n 1.0v 194.745n 1.0v 194.755n 1.0v 199.745n 1.0v 199.755n 0.0v 204.745n 0.0v 204.755n 1.0v 209.745n 1.0v 209.755n 0.0v 214.745n 0.0v 214.755n 1.0v 219.745n 1.0v 219.755n 0.0v 224.745n 0.0v 224.755n 0.0v 229.745n 0.0v 229.755n 1.0v 234.745n 1.0v 234.755n 1.0v 239.745n 1.0v 239.755n 0.0v 244.745n 0.0v 244.755n 1.0v 249.745n 1.0v 249.755n 1.0v 254.745n 1.0v 254.755n 0.0v 259.745n 0.0v 259.755n 1.0v 264.745n 1.0v 264.755n 1.0v 269.745n 1.0v 269.755n 1.0v 274.745n 1.0v 274.755n 0.0v 279.745n 0.0v 279.755n 1.0v 284.745n 1.0v 284.755n 0.0v 289.745n 0.0v 289.755n 0.0v 294.745n 0.0v 294.755n 0.0v 299.745n 0.0v 299.755n 0.0v 304.745n 0.0v 304.755n 1.0v 309.745n 1.0v 309.755n 1.0v 314.745n 1.0v 314.755n 0.0v 319.745n 0.0v 319.755n 0.0v 324.745n 0.0v 324.755n 0.0v 329.745n 0.0v 329.755n 0.0v 334.745n 0.0v 334.755n 0.0v 339.745n 0.0v 339.755n 1.0v 344.745n 1.0v 344.755n 0.0v 349.745n 0.0v 349.755n 0.0v 354.745n 0.0v 354.755n 0.0v 359.745n 0.0v 359.755n 0.0v 364.745n 0.0v 364.755n 0.0v 369.745n 0.0v 369.755n 1.0v 374.745n 1.0v 374.755n 1.0v 379.745n 1.0v 379.755n 0.0v 384.745n 0.0v 384.755n 0.0v 389.745n 0.0v 389.755n 1.0v 394.745n 1.0v 394.755n 0.0v 399.745n 0.0v 399.755n 0.0v 404.745n 0.0v 404.755n 1.0v 409.745n 1.0v 409.755n 0.0v 414.745n 0.0v 414.755n 0.0v 419.745n 0.0v 419.755n 1.0v 424.745n 1.0v 424.755n 1.0v 429.745n 1.0v 429.755n 0.0v 434.745n 0.0v 434.755n 0.0v 439.745n 0.0v 439.755n 0.0v 444.745n 0.0v 444.755n 1.0v 449.745n 1.0v 449.755n 0.0v 454.745n 0.0v 454.755n 1.0v 459.745n 1.0v 459.755n 0.0v 464.745n 0.0v 464.755n 0.0v 469.745n 0.0v 469.755n 1.0v 474.745n 1.0v 474.755n 1.0v 479.745n 1.0v 479.755n 0.0v 484.745n 0.0v 484.755n 0.0v 489.745n 0.0v 489.755n 0.0v 494.745n 0.0v 494.755n 1.0v 499.745n 1.0v 499.755n 0.0v 504.745n 0.0v 504.755n 1.0v 509.745n 1.0v 509.755n 1.0v 514.745n 1.0v 514.755n 0.0v 519.745n 0.0v 519.755n 0.0v 524.745n 0.0v 524.755n 0.0v 529.745n 0.0v 529.755n 0.0v 534.745n 0.0v 534.755n 1.0v 539.745n 1.0v 539.755n 1.0v 544.745n 1.0v 544.755n 1.0v 549.745n 1.0v 549.755n 1.0v 554.745n 1.0v 554.755n 1.0v 559.745n 1.0v 559.755n 1.0v 564.745n 1.0v 564.755n 1.0v 569.745n 1.0v 569.755n 0.0v 574.745n 0.0v 574.755n 1.0v 579.745n 1.0v 579.755n 1.0v 584.745n 1.0v 584.755n 0.0v 589.745n 0.0v 589.755n 0.0v 594.745n 0.0v 594.755n 0.0v 599.745n 0.0v 599.755n 0.0v 604.745n 0.0v 604.755n 0.0v 609.745n 0.0v 609.755n 1.0v 614.745n 1.0v 614.755n 0.0v 619.745n 0.0v 619.755n 0.0v 624.745n 0.0v 624.755n 1.0v 629.745n 1.0v 629.755n 0.0v 634.745n 0.0v 634.755n 1.0v 639.745n 1.0v 639.755n 0.0v 644.745n 0.0v 644.755n 1.0v 649.745n 1.0v 649.755n 1.0v 654.745n 1.0v 654.755n 0.0v 659.745n 0.0v 659.755n 1.0v 664.745n 1.0v 664.755n 1.0v 669.745n 1.0v 669.755n 1.0v 674.745n 1.0v 674.755n 0.0v 679.745n 0.0v 679.755n 1.0v 684.745n 1.0v 684.755n 0.0v 689.745n 0.0v 689.755n 0.0v 694.745n 0.0v 694.755n 1.0v 699.745n 1.0v 699.755n 1.0v 704.745n 1.0v 704.755n 1.0v 709.745n 1.0v 709.755n 0.0v 714.745n 0.0v 714.755n 1.0v 719.745n 1.0v 719.755n 0.0v 724.745n 0.0v 724.755n 1.0v 729.745n 1.0v 729.755n 0.0v 734.745n 0.0v 734.755n 0.0v 739.745n 0.0v 739.755n 0.0v 744.745n 0.0v 744.755n 0.0v 749.745n 0.0v 749.755n 1.0v 754.745n 1.0v 754.755n 1.0v 759.745n 1.0v 759.755n 0.0v 764.745n 0.0v 764.755n 1.0v 769.745n 1.0v 769.755n 1.0v 774.745n 1.0v 774.755n 0.0v 779.745n 0.0v 779.755n 0.0v 784.745n 0.0v 784.755n 0.0v 789.745n 0.0v 789.755n 1.0v 794.745n 1.0v 794.755n 1.0v 799.745n 1.0v 799.755n 0.0v 804.745n 0.0v 804.755n 1.0v 809.745n 1.0v 809.755n 1.0v 814.745n 1.0v 814.755n 1.0v 819.745n 1.0v 819.755n 1.0v 824.745n 1.0v 824.755n 1.0v 829.745n 1.0v 829.755n 1.0v 834.745n 1.0v 834.755n 1.0v 839.745n 1.0v 839.755n 1.0v 844.745n 1.0v 844.755n 0.0v 849.745n 0.0v 849.755n 0.0v 854.745n 0.0v 854.755n 0.0v 859.745n 0.0v 859.755n 0.0v 864.745n 0.0v 864.755n 0.0v 869.745n 0.0v 869.755n 0.0v 874.745n 0.0v 874.755n 1.0v 879.745n 1.0v 879.755n 0.0v 884.745n 0.0v 884.755n 0.0v 889.745n 0.0v 889.755n 0.0v 894.745n 0.0v 894.755n 1.0v 899.745n 1.0v 899.755n 1.0v 904.745n 1.0v 904.755n 0.0v 909.745n 0.0v 909.755n 0.0v 914.745n 0.0v 914.755n 0.0v 919.745n 0.0v 919.755n 1.0v 924.745n 1.0v 924.755n 1.0v 929.745n 1.0v 929.755n 1.0v 934.745n 1.0v 934.755n 0.0v 939.745n 0.0v 939.755n 0.0v 944.745n 0.0v 944.755n 0.0v 949.745n 0.0v 949.755n 0.0v 954.745n 0.0v 954.755n 1.0v 959.745n 1.0v 959.755n 1.0v 964.745n 1.0v 964.755n 0.0v 969.745n 0.0v 969.755n 1.0v 974.745n 1.0v 974.755n 0.0v 979.745n 0.0v 979.755n 1.0v 984.745n 1.0v 984.755n 1.0v 989.745n 1.0v 989.755n 1.0v 994.745n 1.0v 994.755n 0.0v 999.745n 0.0v 999.755n 0.0v 1004.745n 0.0v 1004.755n 0.0v 1009.745n 0.0v 1009.755n 0.0v 1014.745n 0.0v 1014.755n 1.0v 1019.745n 1.0v 1019.755n 1.0v 1024.745n 1.0v 1024.755n 1.0v )
* (time, data): [(0, 0), (5, 0), (10, 0), (15, 1), (20, 0), (25, 0), (30, 0), (35, 0), (40, 1), (45, 1), (50, 1), (55, 0), (60, 0), (65, 0), (70, 0), (75, 1), (80, 1), (85, 0), (90, 0), (95, 0), (100, 1), (105, 0), (110, 0), (115, 0), (120, 1), (125, 1), (130, 0), (135, 0), (140, 0), (145, 0), (150, 1), (155, 1), (160, 1), (165, 0), (170, 0), (175, 0), (180, 0), (185, 0), (190, 0), (195, 0), (200, 1), (205, 0), (210, 1), (215, 0), (220, 1), (225, 1), (230, 0), (235, 0), (240, 0), (245, 1), (250, 1), (255, 0), (260, 0), (265, 0), (270, 0), (275, 0), (280, 0), (285, 0), (290, 0), (295, 1), (300, 0), (305, 0), (310, 0), (315, 0), (320, 1), (325, 1), (330, 1), (335, 1), (340, 0), (345, 1), (350, 0), (355, 0), (360, 0), (365, 1), (370, 0), (375, 0), (380, 1), (385, 1), (390, 0), (395, 1), (400, 1), (405, 0), (410, 0), (415, 0), (420, 1), (425, 0), (430, 1), (435, 0), (440, 0), (445, 0), (450, 0), (455, 1), (460, 0), (465, 0), (470, 1), (475, 1), (480, 1), (485, 0), (490, 0), (495, 0), (500, 0), (505, 0), (510, 0), (515, 1), (520, 1), (525, 0), (530, 0), (535, 0), (540, 0), (545, 1), (550, 1), (555, 1), (560, 0), (565, 0), (570, 0), (575, 0), (580, 0), (585, 1), (590, 1), (595, 1), (600, 1), (605, 1), (610, 0), (615, 1), (620, 1), (625, 1), (630, 0), (635, 0), (640, 0), (645, 0), (650, 0), (655, 1), (660, 0), (665, 0), (670, 0), (675, 1), (680, 0), (685, 1), (690, 1), (695, 0), (700, 1), (705, 1), (710, 0), (715, 0), (720, 1), (725, 0), (730, 1), (735, 1), (740, 1), (745, 1), (750, 1), (755, 1), (760, 0), (765, 1), (770, 1), (775, 1), (780, 1), (785, 1), (790, 0), (795, 1), (800, 1), (805, 0), (810, 0), (815, 0), (820, 0), (825, 0), (830, 0), (835, 0), (840, 1), (845, 0), (850, 0), (855, 1), (860, 1), (865, 1), (870, 1), (875, 1), (880, 1), (885, 1), (890, 1), (895, 1), (900, 1), (905, 1), (910, 1), (915, 1), (920, 0), (925, 0), (930, 0), (935, 1), (940, 1), (945, 0), (950, 0), (955, 0), (960, 0), (965, 1), (970, 0), (975, 1), (980, 0), (985, 0), (990, 0), (995, 0), (1000, 0), (1005, 1), (1010, 1), (1015, 0), (1020, 0), (1025, 0)]
Va0_3  a0_3  0 PWL (0n 0.0v 4.745n 0.0v 4.755n 0.0v 9.745n 0.0v 9.755n 0.0v 14.745n 0.0v 14.755n 1.0v 19.745n 1.0v 19.755n 0.0v 24.745n 0.0v 24.755n 0.0v 29.745n 0.0v 29.755n 0.0v 34.745n 0.0v 34.755n 0.0v 39.745n 0.0v 39.755n 1.0v 44.745n 1.0v 44.755n 1.0v 49.745n 1.0v 49.755n 1.0v 54.745n 1.0v 54.755n 0.0v 59.745n 0.0v 59.755n 0.0v 64.745n 0.0v 64.755n 0.0v 69.745n 0.0v 69.755n 0.0v 74.745n 0.0v 74.755n 1.0v 79.745n 1.0v 79.755n 1.0v 84.745n 1.0v 84.755n 0.0v 89.745n 0.0v 89.755n 0.0v 94.745n 0.0v 94.755n 0.0v 99.745n 0.0v 99.755n 1.0v 104.745n 1.0v 104.755n 0.0v 109.745n 0.0v 109.755n 0.0v 114.745n 0.0v 114.755n 0.0v 119.745n 0.0v 119.755n 1.0v 124.745n 1.0v 124.755n 1.0v 129.745n 1.0v 129.755n 0.0v 134.745n 0.0v 134.755n 0.0v 139.745n 0.0v 139.755n 0.0v 144.745n 0.0v 144.755n 0.0v 149.745n 0.0v 149.755n 1.0v 154.745n 1.0v 154.755n 1.0v 159.745n 1.0v 159.755n 1.0v 164.745n 1.0v 164.755n 0.0v 169.745n 0.0v 169.755n 0.0v 174.745n 0.0v 174.755n 0.0v 179.745n 0.0v 179.755n 0.0v 184.745n 0.0v 184.755n 0.0v 189.745n 0.0v 189.755n 0.0v 194.745n 0.0v 194.755n 0.0v 199.745n 0.0v 199.755n 1.0v 204.745n 1.0v 204.755n 0.0v 209.745n 0.0v 209.755n 1.0v 214.745n 1.0v 214.755n 0.0v 219.745n 0.0v 219.755n 1.0v 224.745n 1.0v 224.755n 1.0v 229.745n 1.0v 229.755n 0.0v 234.745n 0.0v 234.755n 0.0v 239.745n 0.0v 239.755n 0.0v 244.745n 0.0v 244.755n 1.0v 249.745n 1.0v 249.755n 1.0v 254.745n 1.0v 254.755n 0.0v 259.745n 0.0v 259.755n 0.0v 264.745n 0.0v 264.755n 0.0v 269.745n 0.0v 269.755n 0.0v 274.745n 0.0v 274.755n 0.0v 279.745n 0.0v 279.755n 0.0v 284.745n 0.0v 284.755n 0.0v 289.745n 0.0v 289.755n 0.0v 294.745n 0.0v 294.755n 1.0v 299.745n 1.0v 299.755n 0.0v 304.745n 0.0v 304.755n 0.0v 309.745n 0.0v 309.755n 0.0v 314.745n 0.0v 314.755n 0.0v 319.745n 0.0v 319.755n 1.0v 324.745n 1.0v 324.755n 1.0v 329.745n 1.0v 329.755n 1.0v 334.745n 1.0v 334.755n 1.0v 339.745n 1.0v 339.755n 0.0v 344.745n 0.0v 344.755n 1.0v 349.745n 1.0v 349.755n 0.0v 354.745n 0.0v 354.755n 0.0v 359.745n 0.0v 359.755n 0.0v 364.745n 0.0v 364.755n 1.0v 369.745n 1.0v 369.755n 0.0v 374.745n 0.0v 374.755n 0.0v 379.745n 0.0v 379.755n 1.0v 384.745n 1.0v 384.755n 1.0v 389.745n 1.0v 389.755n 0.0v 394.745n 0.0v 394.755n 1.0v 399.745n 1.0v 399.755n 1.0v 404.745n 1.0v 404.755n 0.0v 409.745n 0.0v 409.755n 0.0v 414.745n 0.0v 414.755n 0.0v 419.745n 0.0v 419.755n 1.0v 424.745n 1.0v 424.755n 0.0v 429.745n 0.0v 429.755n 1.0v 434.745n 1.0v 434.755n 0.0v 439.745n 0.0v 439.755n 0.0v 444.745n 0.0v 444.755n 0.0v 449.745n 0.0v 449.755n 0.0v 454.745n 0.0v 454.755n 1.0v 459.745n 1.0v 459.755n 0.0v 464.745n 0.0v 464.755n 0.0v 469.745n 0.0v 469.755n 1.0v 474.745n 1.0v 474.755n 1.0v 479.745n 1.0v 479.755n 1.0v 484.745n 1.0v 484.755n 0.0v 489.745n 0.0v 489.755n 0.0v 494.745n 0.0v 494.755n 0.0v 499.745n 0.0v 499.755n 0.0v 504.745n 0.0v 504.755n 0.0v 509.745n 0.0v 509.755n 0.0v 514.745n 0.0v 514.755n 1.0v 519.745n 1.0v 519.755n 1.0v 524.745n 1.0v 524.755n 0.0v 529.745n 0.0v 529.755n 0.0v 534.745n 0.0v 534.755n 0.0v 539.745n 0.0v 539.755n 0.0v 544.745n 0.0v 544.755n 1.0v 549.745n 1.0v 549.755n 1.0v 554.745n 1.0v 554.755n 1.0v 559.745n 1.0v 559.755n 0.0v 564.745n 0.0v 564.755n 0.0v 569.745n 0.0v 569.755n 0.0v 574.745n 0.0v 574.755n 0.0v 579.745n 0.0v 579.755n 0.0v 584.745n 0.0v 584.755n 1.0v 589.745n 1.0v 589.755n 1.0v 594.745n 1.0v 594.755n 1.0v 599.745n 1.0v 599.755n 1.0v 604.745n 1.0v 604.755n 1.0v 609.745n 1.0v 609.755n 0.0v 614.745n 0.0v 614.755n 1.0v 619.745n 1.0v 619.755n 1.0v 624.745n 1.0v 624.755n 1.0v 629.745n 1.0v 629.755n 0.0v 634.745n 0.0v 634.755n 0.0v 639.745n 0.0v 639.755n 0.0v 644.745n 0.0v 644.755n 0.0v 649.745n 0.0v 649.755n 0.0v 654.745n 0.0v 654.755n 1.0v 659.745n 1.0v 659.755n 0.0v 664.745n 0.0v 664.755n 0.0v 669.745n 0.0v 669.755n 0.0v 674.745n 0.0v 674.755n 1.0v 679.745n 1.0v 679.755n 0.0v 684.745n 0.0v 684.755n 1.0v 689.745n 1.0v 689.755n 1.0v 694.745n 1.0v 694.755n 0.0v 699.745n 0.0v 699.755n 1.0v 704.745n 1.0v 704.755n 1.0v 709.745n 1.0v 709.755n 0.0v 714.745n 0.0v 714.755n 0.0v 719.745n 0.0v 719.755n 1.0v 724.745n 1.0v 724.755n 0.0v 729.745n 0.0v 729.755n 1.0v 734.745n 1.0v 734.755n 1.0v 739.745n 1.0v 739.755n 1.0v 744.745n 1.0v 744.755n 1.0v 749.745n 1.0v 749.755n 1.0v 754.745n 1.0v 754.755n 1.0v 759.745n 1.0v 759.755n 0.0v 764.745n 0.0v 764.755n 1.0v 769.745n 1.0v 769.755n 1.0v 774.745n 1.0v 774.755n 1.0v 779.745n 1.0v 779.755n 1.0v 784.745n 1.0v 784.755n 1.0v 789.745n 1.0v 789.755n 0.0v 794.745n 0.0v 794.755n 1.0v 799.745n 1.0v 799.755n 1.0v 804.745n 1.0v 804.755n 0.0v 809.745n 0.0v 809.755n 0.0v 814.745n 0.0v 814.755n 0.0v 819.745n 0.0v 819.755n 0.0v 824.745n 0.0v 824.755n 0.0v 829.745n 0.0v 829.755n 0.0v 834.745n 0.0v 834.755n 0.0v 839.745n 0.0v 839.755n 1.0v 844.745n 1.0v 844.755n 0.0v 849.745n 0.0v 849.755n 0.0v 854.745n 0.0v 854.755n 1.0v 859.745n 1.0v 859.755n 1.0v 864.745n 1.0v 864.755n 1.0v 869.745n 1.0v 869.755n 1.0v 874.745n 1.0v 874.755n 1.0v 879.745n 1.0v 879.755n 1.0v 884.745n 1.0v 884.755n 1.0v 889.745n 1.0v 889.755n 1.0v 894.745n 1.0v 894.755n 1.0v 899.745n 1.0v 899.755n 1.0v 904.745n 1.0v 904.755n 1.0v 909.745n 1.0v 909.755n 1.0v 914.745n 1.0v 914.755n 1.0v 919.745n 1.0v 919.755n 0.0v 924.745n 0.0v 924.755n 0.0v 929.745n 0.0v 929.755n 0.0v 934.745n 0.0v 934.755n 1.0v 939.745n 1.0v 939.755n 1.0v 944.745n 1.0v 944.755n 0.0v 949.745n 0.0v 949.755n 0.0v 954.745n 0.0v 954.755n 0.0v 959.745n 0.0v 959.755n 0.0v 964.745n 0.0v 964.755n 1.0v 969.745n 1.0v 969.755n 0.0v 974.745n 0.0v 974.755n 1.0v 979.745n 1.0v 979.755n 0.0v 984.745n 0.0v 984.755n 0.0v 989.745n 0.0v 989.755n 0.0v 994.745n 0.0v 994.755n 0.0v 999.745n 0.0v 999.755n 0.0v 1004.745n 0.0v 1004.755n 1.0v 1009.745n 1.0v 1009.755n 1.0v 1014.745n 1.0v 1014.755n 0.0v 1019.745n 0.0v 1019.755n 0.0v 1024.745n 0.0v 1024.755n 0.0v )
* (time, data): [(0, 0), (5, 0), (10, 0), (15, 1), (20, 0), (25, 0), (30, 0), (35, 0), (40, 1), (45, 1), (50, 1), (55, 0), (60, 1), (65, 1), (70, 0), (75, 1), (80, 1), (85, 0), (90, 0), (95, 0), (100, 1), (105, 0), (110, 1), (115, 0), (120, 1), (125, 1), (130, 0), (135, 0), (140, 0), (145, 0), (150, 1), (155, 1), (160, 1), (165, 0), (170, 0), (175, 1), (180, 1), (185, 0), (190, 1), (195, 1), (200, 1), (205, 0), (210, 1), (215, 1), (220, 1), (225, 1), (230, 0), (235, 0), (240, 0), (245, 1), (250, 1), (255, 0), (260, 0), (265, 0), (270, 0), (275, 0), (280, 1), (285, 0), (290, 0), (295, 1), (300, 0), (305, 0), (310, 0), (315, 0), (320, 1), (325, 1), (330, 1), (335, 1), (340, 0), (345, 1), (350, 0), (355, 0), (360, 0), (365, 1), (370, 0), (375, 0), (380, 1), (385, 1), (390, 1), (395, 1), (400, 1), (405, 1), (410, 0), (415, 0), (420, 1), (425, 1), (430, 1), (435, 0), (440, 0), (445, 0), (450, 0), (455, 1), (460, 0), (465, 0), (470, 1), (475, 1), (480, 1), (485, 0), (490, 0), (495, 0), (500, 0), (505, 0), (510, 0), (515, 1), (520, 1), (525, 0), (530, 0), (535, 1), (540, 1), (545, 1), (550, 1), (555, 1), (560, 1), (565, 1), (570, 0), (575, 0), (580, 0), (585, 1), (590, 1), (595, 1), (600, 1), (605, 1), (610, 0), (615, 1), (620, 1), (625, 1), (630, 0), (635, 0), (640, 0), (645, 0), (650, 0), (655, 1), (660, 0), (665, 0), (670, 0), (675, 1), (680, 0), (685, 1), (690, 1), (695, 0), (700, 1), (705, 1), (710, 0), (715, 0), (720, 1), (725, 1), (730, 1), (735, 1), (740, 1), (745, 1), (750, 1), (755, 1), (760, 0), (765, 1), (770, 1), (775, 1), (780, 1), (785, 1), (790, 0), (795, 1), (800, 1), (805, 0), (810, 0), (815, 0), (820, 0), (825, 0), (830, 0), (835, 0), (840, 1), (845, 0), (850, 0), (855, 1), (860, 1), (865, 1), (870, 1), (875, 1), (880, 1), (885, 1), (890, 1), (895, 1), (900, 1), (905, 1), (910, 1), (915, 1), (920, 1), (925, 0), (930, 1), (935, 1), (940, 1), (945, 0), (950, 0), (955, 0), (960, 0), (965, 1), (970, 0), (975, 1), (980, 1), (985, 1), (990, 1), (995, 0), (1000, 0), (1005, 1), (1010, 1), (1015, 1), (1020, 1), (1025, 1)]
Va0_4  a0_4  0 PWL (0n 0.0v 4.745n 0.0v 4.755n 0.0v 9.745n 0.0v 9.755n 0.0v 14.745n 0.0v 14.755n 1.0v 19.745n 1.0v 19.755n 0.0v 24.745n 0.0v 24.755n 0.0v 29.745n 0.0v 29.755n 0.0v 34.745n 0.0v 34.755n 0.0v 39.745n 0.0v 39.755n 1.0v 44.745n 1.0v 44.755n 1.0v 49.745n 1.0v 49.755n 1.0v 54.745n 1.0v 54.755n 0.0v 59.745n 0.0v 59.755n 1.0v 64.745n 1.0v 64.755n 1.0v 69.745n 1.0v 69.755n 0.0v 74.745n 0.0v 74.755n 1.0v 79.745n 1.0v 79.755n 1.0v 84.745n 1.0v 84.755n 0.0v 89.745n 0.0v 89.755n 0.0v 94.745n 0.0v 94.755n 0.0v 99.745n 0.0v 99.755n 1.0v 104.745n 1.0v 104.755n 0.0v 109.745n 0.0v 109.755n 1.0v 114.745n 1.0v 114.755n 0.0v 119.745n 0.0v 119.755n 1.0v 124.745n 1.0v 124.755n 1.0v 129.745n 1.0v 129.755n 0.0v 134.745n 0.0v 134.755n 0.0v 139.745n 0.0v 139.755n 0.0v 144.745n 0.0v 144.755n 0.0v 149.745n 0.0v 149.755n 1.0v 154.745n 1.0v 154.755n 1.0v 159.745n 1.0v 159.755n 1.0v 164.745n 1.0v 164.755n 0.0v 169.745n 0.0v 169.755n 0.0v 174.745n 0.0v 174.755n 1.0v 179.745n 1.0v 179.755n 1.0v 184.745n 1.0v 184.755n 0.0v 189.745n 0.0v 189.755n 1.0v 194.745n 1.0v 194.755n 1.0v 199.745n 1.0v 199.755n 1.0v 204.745n 1.0v 204.755n 0.0v 209.745n 0.0v 209.755n 1.0v 214.745n 1.0v 214.755n 1.0v 219.745n 1.0v 219.755n 1.0v 224.745n 1.0v 224.755n 1.0v 229.745n 1.0v 229.755n 0.0v 234.745n 0.0v 234.755n 0.0v 239.745n 0.0v 239.755n 0.0v 244.745n 0.0v 244.755n 1.0v 249.745n 1.0v 249.755n 1.0v 254.745n 1.0v 254.755n 0.0v 259.745n 0.0v 259.755n 0.0v 264.745n 0.0v 264.755n 0.0v 269.745n 0.0v 269.755n 0.0v 274.745n 0.0v 274.755n 0.0v 279.745n 0.0v 279.755n 1.0v 284.745n 1.0v 284.755n 0.0v 289.745n 0.0v 289.755n 0.0v 294.745n 0.0v 294.755n 1.0v 299.745n 1.0v 299.755n 0.0v 304.745n 0.0v 304.755n 0.0v 309.745n 0.0v 309.755n 0.0v 314.745n 0.0v 314.755n 0.0v 319.745n 0.0v 319.755n 1.0v 324.745n 1.0v 324.755n 1.0v 329.745n 1.0v 329.755n 1.0v 334.745n 1.0v 334.755n 1.0v 339.745n 1.0v 339.755n 0.0v 344.745n 0.0v 344.755n 1.0v 349.745n 1.0v 349.755n 0.0v 354.745n 0.0v 354.755n 0.0v 359.745n 0.0v 359.755n 0.0v 364.745n 0.0v 364.755n 1.0v 369.745n 1.0v 369.755n 0.0v 374.745n 0.0v 374.755n 0.0v 379.745n 0.0v 379.755n 1.0v 384.745n 1.0v 384.755n 1.0v 389.745n 1.0v 389.755n 1.0v 394.745n 1.0v 394.755n 1.0v 399.745n 1.0v 399.755n 1.0v 404.745n 1.0v 404.755n 1.0v 409.745n 1.0v 409.755n 0.0v 414.745n 0.0v 414.755n 0.0v 419.745n 0.0v 419.755n 1.0v 424.745n 1.0v 424.755n 1.0v 429.745n 1.0v 429.755n 1.0v 434.745n 1.0v 434.755n 0.0v 439.745n 0.0v 439.755n 0.0v 444.745n 0.0v 444.755n 0.0v 449.745n 0.0v 449.755n 0.0v 454.745n 0.0v 454.755n 1.0v 459.745n 1.0v 459.755n 0.0v 464.745n 0.0v 464.755n 0.0v 469.745n 0.0v 469.755n 1.0v 474.745n 1.0v 474.755n 1.0v 479.745n 1.0v 479.755n 1.0v 484.745n 1.0v 484.755n 0.0v 489.745n 0.0v 489.755n 0.0v 494.745n 0.0v 494.755n 0.0v 499.745n 0.0v 499.755n 0.0v 504.745n 0.0v 504.755n 0.0v 509.745n 0.0v 509.755n 0.0v 514.745n 0.0v 514.755n 1.0v 519.745n 1.0v 519.755n 1.0v 524.745n 1.0v 524.755n 0.0v 529.745n 0.0v 529.755n 0.0v 534.745n 0.0v 534.755n 1.0v 539.745n 1.0v 539.755n 1.0v 544.745n 1.0v 544.755n 1.0v 549.745n 1.0v 549.755n 1.0v 554.745n 1.0v 554.755n 1.0v 559.745n 1.0v 559.755n 1.0v 564.745n 1.0v 564.755n 1.0v 569.745n 1.0v 569.755n 0.0v 574.745n 0.0v 574.755n 0.0v 579.745n 0.0v 579.755n 0.0v 584.745n 0.0v 584.755n 1.0v 589.745n 1.0v 589.755n 1.0v 594.745n 1.0v 594.755n 1.0v 599.745n 1.0v 599.755n 1.0v 604.745n 1.0v 604.755n 1.0v 609.745n 1.0v 609.755n 0.0v 614.745n 0.0v 614.755n 1.0v 619.745n 1.0v 619.755n 1.0v 624.745n 1.0v 624.755n 1.0v 629.745n 1.0v 629.755n 0.0v 634.745n 0.0v 634.755n 0.0v 639.745n 0.0v 639.755n 0.0v 644.745n 0.0v 644.755n 0.0v 649.745n 0.0v 649.755n 0.0v 654.745n 0.0v 654.755n 1.0v 659.745n 1.0v 659.755n 0.0v 664.745n 0.0v 664.755n 0.0v 669.745n 0.0v 669.755n 0.0v 674.745n 0.0v 674.755n 1.0v 679.745n 1.0v 679.755n 0.0v 684.745n 0.0v 684.755n 1.0v 689.745n 1.0v 689.755n 1.0v 694.745n 1.0v 694.755n 0.0v 699.745n 0.0v 699.755n 1.0v 704.745n 1.0v 704.755n 1.0v 709.745n 1.0v 709.755n 0.0v 714.745n 0.0v 714.755n 0.0v 719.745n 0.0v 719.755n 1.0v 724.745n 1.0v 724.755n 1.0v 729.745n 1.0v 729.755n 1.0v 734.745n 1.0v 734.755n 1.0v 739.745n 1.0v 739.755n 1.0v 744.745n 1.0v 744.755n 1.0v 749.745n 1.0v 749.755n 1.0v 754.745n 1.0v 754.755n 1.0v 759.745n 1.0v 759.755n 0.0v 764.745n 0.0v 764.755n 1.0v 769.745n 1.0v 769.755n 1.0v 774.745n 1.0v 774.755n 1.0v 779.745n 1.0v 779.755n 1.0v 784.745n 1.0v 784.755n 1.0v 789.745n 1.0v 789.755n 0.0v 794.745n 0.0v 794.755n 1.0v 799.745n 1.0v 799.755n 1.0v 804.745n 1.0v 804.755n 0.0v 809.745n 0.0v 809.755n 0.0v 814.745n 0.0v 814.755n 0.0v 819.745n 0.0v 819.755n 0.0v 824.745n 0.0v 824.755n 0.0v 829.745n 0.0v 829.755n 0.0v 834.745n 0.0v 834.755n 0.0v 839.745n 0.0v 839.755n 1.0v 844.745n 1.0v 844.755n 0.0v 849.745n 0.0v 849.755n 0.0v 854.745n 0.0v 854.755n 1.0v 859.745n 1.0v 859.755n 1.0v 864.745n 1.0v 864.755n 1.0v 869.745n 1.0v 869.755n 1.0v 874.745n 1.0v 874.755n 1.0v 879.745n 1.0v 879.755n 1.0v 884.745n 1.0v 884.755n 1.0v 889.745n 1.0v 889.755n 1.0v 894.745n 1.0v 894.755n 1.0v 899.745n 1.0v 899.755n 1.0v 904.745n 1.0v 904.755n 1.0v 909.745n 1.0v 909.755n 1.0v 914.745n 1.0v 914.755n 1.0v 919.745n 1.0v 919.755n 1.0v 924.745n 1.0v 924.755n 0.0v 929.745n 0.0v 929.755n 1.0v 934.745n 1.0v 934.755n 1.0v 939.745n 1.0v 939.755n 1.0v 944.745n 1.0v 944.755n 0.0v 949.745n 0.0v 949.755n 0.0v 954.745n 0.0v 954.755n 0.0v 959.745n 0.0v 959.755n 0.0v 964.745n 0.0v 964.755n 1.0v 969.745n 1.0v 969.755n 0.0v 974.745n 0.0v 974.755n 1.0v 979.745n 1.0v 979.755n 1.0v 984.745n 1.0v 984.755n 1.0v 989.745n 1.0v 989.755n 1.0v 994.745n 1.0v 994.755n 0.0v 999.745n 0.0v 999.755n 0.0v 1004.745n 0.0v 1004.755n 1.0v 1009.745n 1.0v 1009.755n 1.0v 1014.745n 1.0v 1014.755n 1.0v 1019.745n 1.0v 1019.755n 1.0v 1024.745n 1.0v 1024.755n 1.0v )
* (time, data): [(0, 0), (5, 0), (10, 0), (15, 1), (20, 0), (25, 0), (30, 0), (35, 0), (40, 1), (45, 1), (50, 1), (55, 0), (60, 1), (65, 1), (70, 0), (75, 1), (80, 1), (85, 0), (90, 0), (95, 0), (100, 1), (105, 0), (110, 1), (115, 0), (120, 1), (125, 1), (130, 0), (135, 0), (140, 0), (145, 0), (150, 1), (155, 1), (160, 1), (165, 0), (170, 0), (175, 1), (180, 1), (185, 0), (190, 1), (195, 1), (200, 1), (205, 0), (210, 1), (215, 1), (220, 1), (225, 1), (230, 0), (235, 0), (240, 0), (245, 1), (250, 1), (255, 0), (260, 0), (265, 0), (270, 0), (275, 0), (280, 1), (285, 0), (290, 0), (295, 1), (300, 0), (305, 0), (310, 0), (315, 0), (320, 1), (325, 1), (330, 1), (335, 1), (340, 0), (345, 1), (350, 0), (355, 0), (360, 0), (365, 1), (370, 0), (375, 0), (380, 1), (385, 1), (390, 1), (395, 1), (400, 1), (405, 1), (410, 0), (415, 0), (420, 1), (425, 1), (430, 1), (435, 0), (440, 0), (445, 0), (450, 0), (455, 1), (460, 0), (465, 0), (470, 1), (475, 1), (480, 1), (485, 0), (490, 0), (495, 0), (500, 0), (505, 0), (510, 0), (515, 1), (520, 1), (525, 0), (530, 0), (535, 1), (540, 1), (545, 1), (550, 1), (555, 1), (560, 1), (565, 1), (570, 0), (575, 0), (580, 0), (585, 1), (590, 1), (595, 1), (600, 1), (605, 1), (610, 0), (615, 1), (620, 1), (625, 1), (630, 0), (635, 0), (640, 0), (645, 0), (650, 0), (655, 1), (660, 0), (665, 0), (670, 0), (675, 1), (680, 0), (685, 1), (690, 1), (695, 0), (700, 1), (705, 1), (710, 0), (715, 0), (720, 1), (725, 1), (730, 1), (735, 1), (740, 1), (745, 1), (750, 1), (755, 1), (760, 0), (765, 1), (770, 1), (775, 1), (780, 1), (785, 1), (790, 0), (795, 1), (800, 1), (805, 0), (810, 0), (815, 0), (820, 0), (825, 0), (830, 0), (835, 0), (840, 1), (845, 0), (850, 0), (855, 1), (860, 1), (865, 1), (870, 1), (875, 1), (880, 1), (885, 1), (890, 1), (895, 1), (900, 1), (905, 1), (910, 1), (915, 1), (920, 1), (925, 0), (930, 1), (935, 1), (940, 1), (945, 0), (950, 0), (955, 0), (960, 0), (965, 1), (970, 0), (975, 1), (980, 1), (985, 1), (990, 1), (995, 0), (1000, 0), (1005, 1), (1010, 1), (1015, 1), (1020, 1), (1025, 1)]
Va0_5  a0_5  0 PWL (0n 0.0v 4.745n 0.0v 4.755n 0.0v 9.745n 0.0v 9.755n 0.0v 14.745n 0.0v 14.755n 1.0v 19.745n 1.0v 19.755n 0.0v 24.745n 0.0v 24.755n 0.0v 29.745n 0.0v 29.755n 0.0v 34.745n 0.0v 34.755n 0.0v 39.745n 0.0v 39.755n 1.0v 44.745n 1.0v 44.755n 1.0v 49.745n 1.0v 49.755n 1.0v 54.745n 1.0v 54.755n 0.0v 59.745n 0.0v 59.755n 1.0v 64.745n 1.0v 64.755n 1.0v 69.745n 1.0v 69.755n 0.0v 74.745n 0.0v 74.755n 1.0v 79.745n 1.0v 79.755n 1.0v 84.745n 1.0v 84.755n 0.0v 89.745n 0.0v 89.755n 0.0v 94.745n 0.0v 94.755n 0.0v 99.745n 0.0v 99.755n 1.0v 104.745n 1.0v 104.755n 0.0v 109.745n 0.0v 109.755n 1.0v 114.745n 1.0v 114.755n 0.0v 119.745n 0.0v 119.755n 1.0v 124.745n 1.0v 124.755n 1.0v 129.745n 1.0v 129.755n 0.0v 134.745n 0.0v 134.755n 0.0v 139.745n 0.0v 139.755n 0.0v 144.745n 0.0v 144.755n 0.0v 149.745n 0.0v 149.755n 1.0v 154.745n 1.0v 154.755n 1.0v 159.745n 1.0v 159.755n 1.0v 164.745n 1.0v 164.755n 0.0v 169.745n 0.0v 169.755n 0.0v 174.745n 0.0v 174.755n 1.0v 179.745n 1.0v 179.755n 1.0v 184.745n 1.0v 184.755n 0.0v 189.745n 0.0v 189.755n 1.0v 194.745n 1.0v 194.755n 1.0v 199.745n 1.0v 199.755n 1.0v 204.745n 1.0v 204.755n 0.0v 209.745n 0.0v 209.755n 1.0v 214.745n 1.0v 214.755n 1.0v 219.745n 1.0v 219.755n 1.0v 224.745n 1.0v 224.755n 1.0v 229.745n 1.0v 229.755n 0.0v 234.745n 0.0v 234.755n 0.0v 239.745n 0.0v 239.755n 0.0v 244.745n 0.0v 244.755n 1.0v 249.745n 1.0v 249.755n 1.0v 254.745n 1.0v 254.755n 0.0v 259.745n 0.0v 259.755n 0.0v 264.745n 0.0v 264.755n 0.0v 269.745n 0.0v 269.755n 0.0v 274.745n 0.0v 274.755n 0.0v 279.745n 0.0v 279.755n 1.0v 284.745n 1.0v 284.755n 0.0v 289.745n 0.0v 289.755n 0.0v 294.745n 0.0v 294.755n 1.0v 299.745n 1.0v 299.755n 0.0v 304.745n 0.0v 304.755n 0.0v 309.745n 0.0v 309.755n 0.0v 314.745n 0.0v 314.755n 0.0v 319.745n 0.0v 319.755n 1.0v 324.745n 1.0v 324.755n 1.0v 329.745n 1.0v 329.755n 1.0v 334.745n 1.0v 334.755n 1.0v 339.745n 1.0v 339.755n 0.0v 344.745n 0.0v 344.755n 1.0v 349.745n 1.0v 349.755n 0.0v 354.745n 0.0v 354.755n 0.0v 359.745n 0.0v 359.755n 0.0v 364.745n 0.0v 364.755n 1.0v 369.745n 1.0v 369.755n 0.0v 374.745n 0.0v 374.755n 0.0v 379.745n 0.0v 379.755n 1.0v 384.745n 1.0v 384.755n 1.0v 389.745n 1.0v 389.755n 1.0v 394.745n 1.0v 394.755n 1.0v 399.745n 1.0v 399.755n 1.0v 404.745n 1.0v 404.755n 1.0v 409.745n 1.0v 409.755n 0.0v 414.745n 0.0v 414.755n 0.0v 419.745n 0.0v 419.755n 1.0v 424.745n 1.0v 424.755n 1.0v 429.745n 1.0v 429.755n 1.0v 434.745n 1.0v 434.755n 0.0v 439.745n 0.0v 439.755n 0.0v 444.745n 0.0v 444.755n 0.0v 449.745n 0.0v 449.755n 0.0v 454.745n 0.0v 454.755n 1.0v 459.745n 1.0v 459.755n 0.0v 464.745n 0.0v 464.755n 0.0v 469.745n 0.0v 469.755n 1.0v 474.745n 1.0v 474.755n 1.0v 479.745n 1.0v 479.755n 1.0v 484.745n 1.0v 484.755n 0.0v 489.745n 0.0v 489.755n 0.0v 494.745n 0.0v 494.755n 0.0v 499.745n 0.0v 499.755n 0.0v 504.745n 0.0v 504.755n 0.0v 509.745n 0.0v 509.755n 0.0v 514.745n 0.0v 514.755n 1.0v 519.745n 1.0v 519.755n 1.0v 524.745n 1.0v 524.755n 0.0v 529.745n 0.0v 529.755n 0.0v 534.745n 0.0v 534.755n 1.0v 539.745n 1.0v 539.755n 1.0v 544.745n 1.0v 544.755n 1.0v 549.745n 1.0v 549.755n 1.0v 554.745n 1.0v 554.755n 1.0v 559.745n 1.0v 559.755n 1.0v 564.745n 1.0v 564.755n 1.0v 569.745n 1.0v 569.755n 0.0v 574.745n 0.0v 574.755n 0.0v 579.745n 0.0v 579.755n 0.0v 584.745n 0.0v 584.755n 1.0v 589.745n 1.0v 589.755n 1.0v 594.745n 1.0v 594.755n 1.0v 599.745n 1.0v 599.755n 1.0v 604.745n 1.0v 604.755n 1.0v 609.745n 1.0v 609.755n 0.0v 614.745n 0.0v 614.755n 1.0v 619.745n 1.0v 619.755n 1.0v 624.745n 1.0v 624.755n 1.0v 629.745n 1.0v 629.755n 0.0v 634.745n 0.0v 634.755n 0.0v 639.745n 0.0v 639.755n 0.0v 644.745n 0.0v 644.755n 0.0v 649.745n 0.0v 649.755n 0.0v 654.745n 0.0v 654.755n 1.0v 659.745n 1.0v 659.755n 0.0v 664.745n 0.0v 664.755n 0.0v 669.745n 0.0v 669.755n 0.0v 674.745n 0.0v 674.755n 1.0v 679.745n 1.0v 679.755n 0.0v 684.745n 0.0v 684.755n 1.0v 689.745n 1.0v 689.755n 1.0v 694.745n 1.0v 694.755n 0.0v 699.745n 0.0v 699.755n 1.0v 704.745n 1.0v 704.755n 1.0v 709.745n 1.0v 709.755n 0.0v 714.745n 0.0v 714.755n 0.0v 719.745n 0.0v 719.755n 1.0v 724.745n 1.0v 724.755n 1.0v 729.745n 1.0v 729.755n 1.0v 734.745n 1.0v 734.755n 1.0v 739.745n 1.0v 739.755n 1.0v 744.745n 1.0v 744.755n 1.0v 749.745n 1.0v 749.755n 1.0v 754.745n 1.0v 754.755n 1.0v 759.745n 1.0v 759.755n 0.0v 764.745n 0.0v 764.755n 1.0v 769.745n 1.0v 769.755n 1.0v 774.745n 1.0v 774.755n 1.0v 779.745n 1.0v 779.755n 1.0v 784.745n 1.0v 784.755n 1.0v 789.745n 1.0v 789.755n 0.0v 794.745n 0.0v 794.755n 1.0v 799.745n 1.0v 799.755n 1.0v 804.745n 1.0v 804.755n 0.0v 809.745n 0.0v 809.755n 0.0v 814.745n 0.0v 814.755n 0.0v 819.745n 0.0v 819.755n 0.0v 824.745n 0.0v 824.755n 0.0v 829.745n 0.0v 829.755n 0.0v 834.745n 0.0v 834.755n 0.0v 839.745n 0.0v 839.755n 1.0v 844.745n 1.0v 844.755n 0.0v 849.745n 0.0v 849.755n 0.0v 854.745n 0.0v 854.755n 1.0v 859.745n 1.0v 859.755n 1.0v 864.745n 1.0v 864.755n 1.0v 869.745n 1.0v 869.755n 1.0v 874.745n 1.0v 874.755n 1.0v 879.745n 1.0v 879.755n 1.0v 884.745n 1.0v 884.755n 1.0v 889.745n 1.0v 889.755n 1.0v 894.745n 1.0v 894.755n 1.0v 899.745n 1.0v 899.755n 1.0v 904.745n 1.0v 904.755n 1.0v 909.745n 1.0v 909.755n 1.0v 914.745n 1.0v 914.755n 1.0v 919.745n 1.0v 919.755n 1.0v 924.745n 1.0v 924.755n 0.0v 929.745n 0.0v 929.755n 1.0v 934.745n 1.0v 934.755n 1.0v 939.745n 1.0v 939.755n 1.0v 944.745n 1.0v 944.755n 0.0v 949.745n 0.0v 949.755n 0.0v 954.745n 0.0v 954.755n 0.0v 959.745n 0.0v 959.755n 0.0v 964.745n 0.0v 964.755n 1.0v 969.745n 1.0v 969.755n 0.0v 974.745n 0.0v 974.755n 1.0v 979.745n 1.0v 979.755n 1.0v 984.745n 1.0v 984.755n 1.0v 989.745n 1.0v 989.755n 1.0v 994.745n 1.0v 994.755n 0.0v 999.745n 0.0v 999.755n 0.0v 1004.745n 0.0v 1004.755n 1.0v 1009.745n 1.0v 1009.755n 1.0v 1014.745n 1.0v 1014.755n 1.0v 1019.745n 1.0v 1019.755n 1.0v 1024.745n 1.0v 1024.755n 1.0v )
* (time, data): [(0, 0), (5, 0), (10, 0), (15, 1), (20, 0), (25, 0), (30, 0), (35, 0), (40, 1), (45, 1), (50, 1), (55, 0), (60, 1), (65, 1), (70, 0), (75, 1), (80, 1), (85, 0), (90, 0), (95, 0), (100, 1), (105, 0), (110, 1), (115, 0), (120, 1), (125, 1), (130, 0), (135, 0), (140, 0), (145, 0), (150, 1), (155, 1), (160, 1), (165, 0), (170, 0), (175, 1), (180, 1), (185, 0), (190, 1), (195, 1), (200, 1), (205, 0), (210, 1), (215, 1), (220, 1), (225, 1), (230, 0), (235, 0), (240, 0), (245, 1), (250, 1), (255, 0), (260, 0), (265, 0), (270, 0), (275, 0), (280, 1), (285, 0), (290, 0), (295, 1), (300, 0), (305, 0), (310, 0), (315, 0), (320, 1), (325, 1), (330, 1), (335, 1), (340, 0), (345, 1), (350, 0), (355, 0), (360, 0), (365, 1), (370, 0), (375, 0), (380, 1), (385, 1), (390, 1), (395, 1), (400, 1), (405, 1), (410, 0), (415, 0), (420, 1), (425, 1), (430, 1), (435, 0), (440, 0), (445, 0), (450, 0), (455, 1), (460, 0), (465, 0), (470, 1), (475, 1), (480, 1), (485, 0), (490, 0), (495, 0), (500, 0), (505, 0), (510, 0), (515, 1), (520, 1), (525, 0), (530, 0), (535, 1), (540, 1), (545, 1), (550, 1), (555, 1), (560, 1), (565, 1), (570, 0), (575, 0), (580, 0), (585, 1), (590, 1), (595, 1), (600, 1), (605, 1), (610, 0), (615, 1), (620, 1), (625, 1), (630, 0), (635, 0), (640, 0), (645, 0), (650, 0), (655, 1), (660, 0), (665, 0), (670, 0), (675, 1), (680, 0), (685, 1), (690, 1), (695, 0), (700, 1), (705, 1), (710, 0), (715, 0), (720, 1), (725, 1), (730, 1), (735, 1), (740, 1), (745, 1), (750, 1), (755, 1), (760, 0), (765, 1), (770, 1), (775, 1), (780, 1), (785, 1), (790, 0), (795, 1), (800, 1), (805, 0), (810, 0), (815, 0), (820, 0), (825, 0), (830, 0), (835, 0), (840, 1), (845, 0), (850, 0), (855, 1), (860, 1), (865, 1), (870, 1), (875, 1), (880, 1), (885, 1), (890, 1), (895, 1), (900, 1), (905, 1), (910, 1), (915, 1), (920, 1), (925, 0), (930, 1), (935, 1), (940, 1), (945, 0), (950, 0), (955, 0), (960, 0), (965, 1), (970, 0), (975, 1), (980, 1), (985, 1), (990, 1), (995, 0), (1000, 0), (1005, 1), (1010, 1), (1015, 1), (1020, 1), (1025, 1)]
Va0_6  a0_6  0 PWL (0n 0.0v 4.745n 0.0v 4.755n 0.0v 9.745n 0.0v 9.755n 0.0v 14.745n 0.0v 14.755n 1.0v 19.745n 1.0v 19.755n 0.0v 24.745n 0.0v 24.755n 0.0v 29.745n 0.0v 29.755n 0.0v 34.745n 0.0v 34.755n 0.0v 39.745n 0.0v 39.755n 1.0v 44.745n 1.0v 44.755n 1.0v 49.745n 1.0v 49.755n 1.0v 54.745n 1.0v 54.755n 0.0v 59.745n 0.0v 59.755n 1.0v 64.745n 1.0v 64.755n 1.0v 69.745n 1.0v 69.755n 0.0v 74.745n 0.0v 74.755n 1.0v 79.745n 1.0v 79.755n 1.0v 84.745n 1.0v 84.755n 0.0v 89.745n 0.0v 89.755n 0.0v 94.745n 0.0v 94.755n 0.0v 99.745n 0.0v 99.755n 1.0v 104.745n 1.0v 104.755n 0.0v 109.745n 0.0v 109.755n 1.0v 114.745n 1.0v 114.755n 0.0v 119.745n 0.0v 119.755n 1.0v 124.745n 1.0v 124.755n 1.0v 129.745n 1.0v 129.755n 0.0v 134.745n 0.0v 134.755n 0.0v 139.745n 0.0v 139.755n 0.0v 144.745n 0.0v 144.755n 0.0v 149.745n 0.0v 149.755n 1.0v 154.745n 1.0v 154.755n 1.0v 159.745n 1.0v 159.755n 1.0v 164.745n 1.0v 164.755n 0.0v 169.745n 0.0v 169.755n 0.0v 174.745n 0.0v 174.755n 1.0v 179.745n 1.0v 179.755n 1.0v 184.745n 1.0v 184.755n 0.0v 189.745n 0.0v 189.755n 1.0v 194.745n 1.0v 194.755n 1.0v 199.745n 1.0v 199.755n 1.0v 204.745n 1.0v 204.755n 0.0v 209.745n 0.0v 209.755n 1.0v 214.745n 1.0v 214.755n 1.0v 219.745n 1.0v 219.755n 1.0v 224.745n 1.0v 224.755n 1.0v 229.745n 1.0v 229.755n 0.0v 234.745n 0.0v 234.755n 0.0v 239.745n 0.0v 239.755n 0.0v 244.745n 0.0v 244.755n 1.0v 249.745n 1.0v 249.755n 1.0v 254.745n 1.0v 254.755n 0.0v 259.745n 0.0v 259.755n 0.0v 264.745n 0.0v 264.755n 0.0v 269.745n 0.0v 269.755n 0.0v 274.745n 0.0v 274.755n 0.0v 279.745n 0.0v 279.755n 1.0v 284.745n 1.0v 284.755n 0.0v 289.745n 0.0v 289.755n 0.0v 294.745n 0.0v 294.755n 1.0v 299.745n 1.0v 299.755n 0.0v 304.745n 0.0v 304.755n 0.0v 309.745n 0.0v 309.755n 0.0v 314.745n 0.0v 314.755n 0.0v 319.745n 0.0v 319.755n 1.0v 324.745n 1.0v 324.755n 1.0v 329.745n 1.0v 329.755n 1.0v 334.745n 1.0v 334.755n 1.0v 339.745n 1.0v 339.755n 0.0v 344.745n 0.0v 344.755n 1.0v 349.745n 1.0v 349.755n 0.0v 354.745n 0.0v 354.755n 0.0v 359.745n 0.0v 359.755n 0.0v 364.745n 0.0v 364.755n 1.0v 369.745n 1.0v 369.755n 0.0v 374.745n 0.0v 374.755n 0.0v 379.745n 0.0v 379.755n 1.0v 384.745n 1.0v 384.755n 1.0v 389.745n 1.0v 389.755n 1.0v 394.745n 1.0v 394.755n 1.0v 399.745n 1.0v 399.755n 1.0v 404.745n 1.0v 404.755n 1.0v 409.745n 1.0v 409.755n 0.0v 414.745n 0.0v 414.755n 0.0v 419.745n 0.0v 419.755n 1.0v 424.745n 1.0v 424.755n 1.0v 429.745n 1.0v 429.755n 1.0v 434.745n 1.0v 434.755n 0.0v 439.745n 0.0v 439.755n 0.0v 444.745n 0.0v 444.755n 0.0v 449.745n 0.0v 449.755n 0.0v 454.745n 0.0v 454.755n 1.0v 459.745n 1.0v 459.755n 0.0v 464.745n 0.0v 464.755n 0.0v 469.745n 0.0v 469.755n 1.0v 474.745n 1.0v 474.755n 1.0v 479.745n 1.0v 479.755n 1.0v 484.745n 1.0v 484.755n 0.0v 489.745n 0.0v 489.755n 0.0v 494.745n 0.0v 494.755n 0.0v 499.745n 0.0v 499.755n 0.0v 504.745n 0.0v 504.755n 0.0v 509.745n 0.0v 509.755n 0.0v 514.745n 0.0v 514.755n 1.0v 519.745n 1.0v 519.755n 1.0v 524.745n 1.0v 524.755n 0.0v 529.745n 0.0v 529.755n 0.0v 534.745n 0.0v 534.755n 1.0v 539.745n 1.0v 539.755n 1.0v 544.745n 1.0v 544.755n 1.0v 549.745n 1.0v 549.755n 1.0v 554.745n 1.0v 554.755n 1.0v 559.745n 1.0v 559.755n 1.0v 564.745n 1.0v 564.755n 1.0v 569.745n 1.0v 569.755n 0.0v 574.745n 0.0v 574.755n 0.0v 579.745n 0.0v 579.755n 0.0v 584.745n 0.0v 584.755n 1.0v 589.745n 1.0v 589.755n 1.0v 594.745n 1.0v 594.755n 1.0v 599.745n 1.0v 599.755n 1.0v 604.745n 1.0v 604.755n 1.0v 609.745n 1.0v 609.755n 0.0v 614.745n 0.0v 614.755n 1.0v 619.745n 1.0v 619.755n 1.0v 624.745n 1.0v 624.755n 1.0v 629.745n 1.0v 629.755n 0.0v 634.745n 0.0v 634.755n 0.0v 639.745n 0.0v 639.755n 0.0v 644.745n 0.0v 644.755n 0.0v 649.745n 0.0v 649.755n 0.0v 654.745n 0.0v 654.755n 1.0v 659.745n 1.0v 659.755n 0.0v 664.745n 0.0v 664.755n 0.0v 669.745n 0.0v 669.755n 0.0v 674.745n 0.0v 674.755n 1.0v 679.745n 1.0v 679.755n 0.0v 684.745n 0.0v 684.755n 1.0v 689.745n 1.0v 689.755n 1.0v 694.745n 1.0v 694.755n 0.0v 699.745n 0.0v 699.755n 1.0v 704.745n 1.0v 704.755n 1.0v 709.745n 1.0v 709.755n 0.0v 714.745n 0.0v 714.755n 0.0v 719.745n 0.0v 719.755n 1.0v 724.745n 1.0v 724.755n 1.0v 729.745n 1.0v 729.755n 1.0v 734.745n 1.0v 734.755n 1.0v 739.745n 1.0v 739.755n 1.0v 744.745n 1.0v 744.755n 1.0v 749.745n 1.0v 749.755n 1.0v 754.745n 1.0v 754.755n 1.0v 759.745n 1.0v 759.755n 0.0v 764.745n 0.0v 764.755n 1.0v 769.745n 1.0v 769.755n 1.0v 774.745n 1.0v 774.755n 1.0v 779.745n 1.0v 779.755n 1.0v 784.745n 1.0v 784.755n 1.0v 789.745n 1.0v 789.755n 0.0v 794.745n 0.0v 794.755n 1.0v 799.745n 1.0v 799.755n 1.0v 804.745n 1.0v 804.755n 0.0v 809.745n 0.0v 809.755n 0.0v 814.745n 0.0v 814.755n 0.0v 819.745n 0.0v 819.755n 0.0v 824.745n 0.0v 824.755n 0.0v 829.745n 0.0v 829.755n 0.0v 834.745n 0.0v 834.755n 0.0v 839.745n 0.0v 839.755n 1.0v 844.745n 1.0v 844.755n 0.0v 849.745n 0.0v 849.755n 0.0v 854.745n 0.0v 854.755n 1.0v 859.745n 1.0v 859.755n 1.0v 864.745n 1.0v 864.755n 1.0v 869.745n 1.0v 869.755n 1.0v 874.745n 1.0v 874.755n 1.0v 879.745n 1.0v 879.755n 1.0v 884.745n 1.0v 884.755n 1.0v 889.745n 1.0v 889.755n 1.0v 894.745n 1.0v 894.755n 1.0v 899.745n 1.0v 899.755n 1.0v 904.745n 1.0v 904.755n 1.0v 909.745n 1.0v 909.755n 1.0v 914.745n 1.0v 914.755n 1.0v 919.745n 1.0v 919.755n 1.0v 924.745n 1.0v 924.755n 0.0v 929.745n 0.0v 929.755n 1.0v 934.745n 1.0v 934.755n 1.0v 939.745n 1.0v 939.755n 1.0v 944.745n 1.0v 944.755n 0.0v 949.745n 0.0v 949.755n 0.0v 954.745n 0.0v 954.755n 0.0v 959.745n 0.0v 959.755n 0.0v 964.745n 0.0v 964.755n 1.0v 969.745n 1.0v 969.755n 0.0v 974.745n 0.0v 974.755n 1.0v 979.745n 1.0v 979.755n 1.0v 984.745n 1.0v 984.755n 1.0v 989.745n 1.0v 989.755n 1.0v 994.745n 1.0v 994.755n 0.0v 999.745n 0.0v 999.755n 0.0v 1004.745n 0.0v 1004.755n 1.0v 1009.745n 1.0v 1009.755n 1.0v 1014.745n 1.0v 1014.755n 1.0v 1019.745n 1.0v 1019.755n 1.0v 1024.745n 1.0v 1024.755n 1.0v )
* (time, data): [(0, 0), (5, 0), (10, 0), (15, 1), (20, 0), (25, 0), (30, 0), (35, 0), (40, 1), (45, 1), (50, 1), (55, 0), (60, 1), (65, 1), (70, 0), (75, 1), (80, 1), (85, 0), (90, 0), (95, 0), (100, 1), (105, 0), (110, 1), (115, 0), (120, 1), (125, 1), (130, 0), (135, 0), (140, 0), (145, 0), (150, 1), (155, 1), (160, 1), (165, 0), (170, 0), (175, 1), (180, 1), (185, 0), (190, 1), (195, 1), (200, 1), (205, 0), (210, 1), (215, 1), (220, 1), (225, 1), (230, 0), (235, 0), (240, 0), (245, 1), (250, 1), (255, 0), (260, 0), (265, 0), (270, 0), (275, 0), (280, 1), (285, 0), (290, 0), (295, 1), (300, 0), (305, 0), (310, 0), (315, 0), (320, 1), (325, 1), (330, 1), (335, 1), (340, 0), (345, 1), (350, 0), (355, 0), (360, 0), (365, 1), (370, 0), (375, 0), (380, 1), (385, 1), (390, 1), (395, 1), (400, 1), (405, 1), (410, 0), (415, 0), (420, 1), (425, 1), (430, 1), (435, 0), (440, 0), (445, 0), (450, 0), (455, 1), (460, 0), (465, 0), (470, 1), (475, 1), (480, 1), (485, 0), (490, 0), (495, 0), (500, 0), (505, 0), (510, 0), (515, 1), (520, 1), (525, 0), (530, 0), (535, 1), (540, 1), (545, 1), (550, 1), (555, 1), (560, 1), (565, 1), (570, 0), (575, 0), (580, 0), (585, 1), (590, 1), (595, 1), (600, 1), (605, 1), (610, 0), (615, 1), (620, 1), (625, 1), (630, 0), (635, 0), (640, 0), (645, 0), (650, 0), (655, 1), (660, 0), (665, 0), (670, 0), (675, 1), (680, 0), (685, 1), (690, 1), (695, 0), (700, 1), (705, 1), (710, 0), (715, 0), (720, 1), (725, 1), (730, 1), (735, 1), (740, 1), (745, 1), (750, 1), (755, 1), (760, 0), (765, 1), (770, 1), (775, 1), (780, 1), (785, 1), (790, 0), (795, 1), (800, 1), (805, 0), (810, 0), (815, 0), (820, 0), (825, 0), (830, 0), (835, 0), (840, 1), (845, 0), (850, 0), (855, 1), (860, 1), (865, 1), (870, 1), (875, 1), (880, 1), (885, 1), (890, 1), (895, 1), (900, 1), (905, 1), (910, 1), (915, 1), (920, 1), (925, 0), (930, 1), (935, 1), (940, 1), (945, 0), (950, 0), (955, 0), (960, 0), (965, 1), (970, 0), (975, 1), (980, 1), (985, 1), (990, 1), (995, 0), (1000, 0), (1005, 1), (1010, 1), (1015, 1), (1020, 1), (1025, 1)]
Va0_7  a0_7  0 PWL (0n 0.0v 4.745n 0.0v 4.755n 0.0v 9.745n 0.0v 9.755n 0.0v 14.745n 0.0v 14.755n 1.0v 19.745n 1.0v 19.755n 0.0v 24.745n 0.0v 24.755n 0.0v 29.745n 0.0v 29.755n 0.0v 34.745n 0.0v 34.755n 0.0v 39.745n 0.0v 39.755n 1.0v 44.745n 1.0v 44.755n 1.0v 49.745n 1.0v 49.755n 1.0v 54.745n 1.0v 54.755n 0.0v 59.745n 0.0v 59.755n 1.0v 64.745n 1.0v 64.755n 1.0v 69.745n 1.0v 69.755n 0.0v 74.745n 0.0v 74.755n 1.0v 79.745n 1.0v 79.755n 1.0v 84.745n 1.0v 84.755n 0.0v 89.745n 0.0v 89.755n 0.0v 94.745n 0.0v 94.755n 0.0v 99.745n 0.0v 99.755n 1.0v 104.745n 1.0v 104.755n 0.0v 109.745n 0.0v 109.755n 1.0v 114.745n 1.0v 114.755n 0.0v 119.745n 0.0v 119.755n 1.0v 124.745n 1.0v 124.755n 1.0v 129.745n 1.0v 129.755n 0.0v 134.745n 0.0v 134.755n 0.0v 139.745n 0.0v 139.755n 0.0v 144.745n 0.0v 144.755n 0.0v 149.745n 0.0v 149.755n 1.0v 154.745n 1.0v 154.755n 1.0v 159.745n 1.0v 159.755n 1.0v 164.745n 1.0v 164.755n 0.0v 169.745n 0.0v 169.755n 0.0v 174.745n 0.0v 174.755n 1.0v 179.745n 1.0v 179.755n 1.0v 184.745n 1.0v 184.755n 0.0v 189.745n 0.0v 189.755n 1.0v 194.745n 1.0v 194.755n 1.0v 199.745n 1.0v 199.755n 1.0v 204.745n 1.0v 204.755n 0.0v 209.745n 0.0v 209.755n 1.0v 214.745n 1.0v 214.755n 1.0v 219.745n 1.0v 219.755n 1.0v 224.745n 1.0v 224.755n 1.0v 229.745n 1.0v 229.755n 0.0v 234.745n 0.0v 234.755n 0.0v 239.745n 0.0v 239.755n 0.0v 244.745n 0.0v 244.755n 1.0v 249.745n 1.0v 249.755n 1.0v 254.745n 1.0v 254.755n 0.0v 259.745n 0.0v 259.755n 0.0v 264.745n 0.0v 264.755n 0.0v 269.745n 0.0v 269.755n 0.0v 274.745n 0.0v 274.755n 0.0v 279.745n 0.0v 279.755n 1.0v 284.745n 1.0v 284.755n 0.0v 289.745n 0.0v 289.755n 0.0v 294.745n 0.0v 294.755n 1.0v 299.745n 1.0v 299.755n 0.0v 304.745n 0.0v 304.755n 0.0v 309.745n 0.0v 309.755n 0.0v 314.745n 0.0v 314.755n 0.0v 319.745n 0.0v 319.755n 1.0v 324.745n 1.0v 324.755n 1.0v 329.745n 1.0v 329.755n 1.0v 334.745n 1.0v 334.755n 1.0v 339.745n 1.0v 339.755n 0.0v 344.745n 0.0v 344.755n 1.0v 349.745n 1.0v 349.755n 0.0v 354.745n 0.0v 354.755n 0.0v 359.745n 0.0v 359.755n 0.0v 364.745n 0.0v 364.755n 1.0v 369.745n 1.0v 369.755n 0.0v 374.745n 0.0v 374.755n 0.0v 379.745n 0.0v 379.755n 1.0v 384.745n 1.0v 384.755n 1.0v 389.745n 1.0v 389.755n 1.0v 394.745n 1.0v 394.755n 1.0v 399.745n 1.0v 399.755n 1.0v 404.745n 1.0v 404.755n 1.0v 409.745n 1.0v 409.755n 0.0v 414.745n 0.0v 414.755n 0.0v 419.745n 0.0v 419.755n 1.0v 424.745n 1.0v 424.755n 1.0v 429.745n 1.0v 429.755n 1.0v 434.745n 1.0v 434.755n 0.0v 439.745n 0.0v 439.755n 0.0v 444.745n 0.0v 444.755n 0.0v 449.745n 0.0v 449.755n 0.0v 454.745n 0.0v 454.755n 1.0v 459.745n 1.0v 459.755n 0.0v 464.745n 0.0v 464.755n 0.0v 469.745n 0.0v 469.755n 1.0v 474.745n 1.0v 474.755n 1.0v 479.745n 1.0v 479.755n 1.0v 484.745n 1.0v 484.755n 0.0v 489.745n 0.0v 489.755n 0.0v 494.745n 0.0v 494.755n 0.0v 499.745n 0.0v 499.755n 0.0v 504.745n 0.0v 504.755n 0.0v 509.745n 0.0v 509.755n 0.0v 514.745n 0.0v 514.755n 1.0v 519.745n 1.0v 519.755n 1.0v 524.745n 1.0v 524.755n 0.0v 529.745n 0.0v 529.755n 0.0v 534.745n 0.0v 534.755n 1.0v 539.745n 1.0v 539.755n 1.0v 544.745n 1.0v 544.755n 1.0v 549.745n 1.0v 549.755n 1.0v 554.745n 1.0v 554.755n 1.0v 559.745n 1.0v 559.755n 1.0v 564.745n 1.0v 564.755n 1.0v 569.745n 1.0v 569.755n 0.0v 574.745n 0.0v 574.755n 0.0v 579.745n 0.0v 579.755n 0.0v 584.745n 0.0v 584.755n 1.0v 589.745n 1.0v 589.755n 1.0v 594.745n 1.0v 594.755n 1.0v 599.745n 1.0v 599.755n 1.0v 604.745n 1.0v 604.755n 1.0v 609.745n 1.0v 609.755n 0.0v 614.745n 0.0v 614.755n 1.0v 619.745n 1.0v 619.755n 1.0v 624.745n 1.0v 624.755n 1.0v 629.745n 1.0v 629.755n 0.0v 634.745n 0.0v 634.755n 0.0v 639.745n 0.0v 639.755n 0.0v 644.745n 0.0v 644.755n 0.0v 649.745n 0.0v 649.755n 0.0v 654.745n 0.0v 654.755n 1.0v 659.745n 1.0v 659.755n 0.0v 664.745n 0.0v 664.755n 0.0v 669.745n 0.0v 669.755n 0.0v 674.745n 0.0v 674.755n 1.0v 679.745n 1.0v 679.755n 0.0v 684.745n 0.0v 684.755n 1.0v 689.745n 1.0v 689.755n 1.0v 694.745n 1.0v 694.755n 0.0v 699.745n 0.0v 699.755n 1.0v 704.745n 1.0v 704.755n 1.0v 709.745n 1.0v 709.755n 0.0v 714.745n 0.0v 714.755n 0.0v 719.745n 0.0v 719.755n 1.0v 724.745n 1.0v 724.755n 1.0v 729.745n 1.0v 729.755n 1.0v 734.745n 1.0v 734.755n 1.0v 739.745n 1.0v 739.755n 1.0v 744.745n 1.0v 744.755n 1.0v 749.745n 1.0v 749.755n 1.0v 754.745n 1.0v 754.755n 1.0v 759.745n 1.0v 759.755n 0.0v 764.745n 0.0v 764.755n 1.0v 769.745n 1.0v 769.755n 1.0v 774.745n 1.0v 774.755n 1.0v 779.745n 1.0v 779.755n 1.0v 784.745n 1.0v 784.755n 1.0v 789.745n 1.0v 789.755n 0.0v 794.745n 0.0v 794.755n 1.0v 799.745n 1.0v 799.755n 1.0v 804.745n 1.0v 804.755n 0.0v 809.745n 0.0v 809.755n 0.0v 814.745n 0.0v 814.755n 0.0v 819.745n 0.0v 819.755n 0.0v 824.745n 0.0v 824.755n 0.0v 829.745n 0.0v 829.755n 0.0v 834.745n 0.0v 834.755n 0.0v 839.745n 0.0v 839.755n 1.0v 844.745n 1.0v 844.755n 0.0v 849.745n 0.0v 849.755n 0.0v 854.745n 0.0v 854.755n 1.0v 859.745n 1.0v 859.755n 1.0v 864.745n 1.0v 864.755n 1.0v 869.745n 1.0v 869.755n 1.0v 874.745n 1.0v 874.755n 1.0v 879.745n 1.0v 879.755n 1.0v 884.745n 1.0v 884.755n 1.0v 889.745n 1.0v 889.755n 1.0v 894.745n 1.0v 894.755n 1.0v 899.745n 1.0v 899.755n 1.0v 904.745n 1.0v 904.755n 1.0v 909.745n 1.0v 909.755n 1.0v 914.745n 1.0v 914.755n 1.0v 919.745n 1.0v 919.755n 1.0v 924.745n 1.0v 924.755n 0.0v 929.745n 0.0v 929.755n 1.0v 934.745n 1.0v 934.755n 1.0v 939.745n 1.0v 939.755n 1.0v 944.745n 1.0v 944.755n 0.0v 949.745n 0.0v 949.755n 0.0v 954.745n 0.0v 954.755n 0.0v 959.745n 0.0v 959.755n 0.0v 964.745n 0.0v 964.755n 1.0v 969.745n 1.0v 969.755n 0.0v 974.745n 0.0v 974.755n 1.0v 979.745n 1.0v 979.755n 1.0v 984.745n 1.0v 984.755n 1.0v 989.745n 1.0v 989.755n 1.0v 994.745n 1.0v 994.755n 0.0v 999.745n 0.0v 999.755n 0.0v 1004.745n 0.0v 1004.755n 1.0v 1009.745n 1.0v 1009.755n 1.0v 1014.745n 1.0v 1014.755n 1.0v 1019.745n 1.0v 1019.755n 1.0v 1024.745n 1.0v 1024.755n 1.0v )

 * Generation of control signals
* (time, data): [(0, 1), (5, 0), (10, 0), (15, 0), (20, 0), (25, 0), (30, 1), (35, 0), (40, 0), (45, 0), (50, 1), (55, 0), (60, 0), (65, 1), (70, 0), (75, 0), (80, 0), (85, 0), (90, 1), (95, 0), (100, 0), (105, 0), (110, 0), (115, 0), (120, 0), (125, 0), (130, 0), (135, 0), (140, 0), (145, 0), (150, 0), (155, 0), (160, 1), (165, 0), (170, 1), (175, 0), (180, 1), (185, 0), (190, 0), (195, 1), (200, 0), (205, 0), (210, 0), (215, 0), (220, 0), (225, 1), (230, 0), (235, 0), (240, 0), (245, 0), (250, 1), (255, 0), (260, 0), (265, 1), (270, 0), (275, 0), (280, 0), (285, 0), (290, 1), (295, 0), (300, 0), (305, 0), (310, 0), (315, 0), (320, 0), (325, 0), (330, 1), (335, 0), (340, 0), (345, 0), (350, 0), (355, 1), (360, 1), (365, 0), (370, 0), (375, 1), (380, 0), (385, 0), (390, 0), (395, 0), (400, 1), (405, 0), (410, 0), (415, 1), (420, 0), (425, 0), (430, 0), (435, 0), (440, 0), (445, 0), (450, 0), (455, 0), (460, 0), (465, 1), (470, 0), (475, 0), (480, 0), (485, 0), (490, 1), (495, 0), (500, 0), (505, 0), (510, 1), (515, 0), (520, 0), (525, 0), (530, 0), (535, 0), (540, 1), (545, 0), (550, 0), (555, 1), (560, 0), (565, 1), (570, 0), (575, 0), (580, 0), (585, 0), (590, 1), (595, 0), (600, 1), (605, 0), (610, 0), (615, 0), (620, 1), (625, 0), (630, 0), (635, 0), (640, 0), (645, 0), (650, 1), (655, 0), (660, 0), (665, 0), (670, 1), (675, 0), (680, 0), (685, 0), (690, 1), (695, 0), (700, 0), (705, 1), (710, 0), (715, 0), (720, 0), (725, 0), (730, 0), (735, 1), (740, 1), (745, 1), (750, 0), (755, 1), (760, 0), (765, 0), (770, 1), (775, 0), (780, 0), (785, 0), (790, 0), (795, 0), (800, 0), (805, 0), (810, 0), (815, 0), (820, 0), (825, 1), (830, 1), (835, 0), (840, 0), (845, 0), (850, 1), (855, 0), (860, 0), (865, 0), (870, 0), (875, 0), (880, 0), (885, 1), (890, 1), (895, 0), (900, 0), (905, 0), (910, 0), (915, 0), (920, 0), (925, 0), (930, 0), (935, 0), (940, 1), (945, 0), (950, 1), (955, 0), (960, 0), (965, 0), (970, 0), (975, 0), (980, 0), (985, 0), (990, 1), (995, 0), (1000, 1), (1005, 0), (1010, 1), (1015, 0), (1020, 1), (1025, 1)]
VCSB0 CSB0 0 PWL (0n 1.0v 4.745n 1.0v 4.755n 0.0v 9.745n 0.0v 9.755n 0.0v 14.745n 0.0v 14.755n 0.0v 19.745n 0.0v 19.755n 0.0v 24.745n 0.0v 24.755n 0.0v 29.745n 0.0v 29.755n 1.0v 34.745n 1.0v 34.755n 0.0v 39.745n 0.0v 39.755n 0.0v 44.745n 0.0v 44.755n 0.0v 49.745n 0.0v 49.755n 1.0v 54.745n 1.0v 54.755n 0.0v 59.745n 0.0v 59.755n 0.0v 64.745n 0.0v 64.755n 1.0v 69.745n 1.0v 69.755n 0.0v 74.745n 0.0v 74.755n 0.0v 79.745n 0.0v 79.755n 0.0v 84.745n 0.0v 84.755n 0.0v 89.745n 0.0v 89.755n 1.0v 94.745n 1.0v 94.755n 0.0v 99.745n 0.0v 99.755n 0.0v 104.745n 0.0v 104.755n 0.0v 109.745n 0.0v 109.755n 0.0v 114.745n 0.0v 114.755n 0.0v 119.745n 0.0v 119.755n 0.0v 124.745n 0.0v 124.755n 0.0v 129.745n 0.0v 129.755n 0.0v 134.745n 0.0v 134.755n 0.0v 139.745n 0.0v 139.755n 0.0v 144.745n 0.0v 144.755n 0.0v 149.745n 0.0v 149.755n 0.0v 154.745n 0.0v 154.755n 0.0v 159.745n 0.0v 159.755n 1.0v 164.745n 1.0v 164.755n 0.0v 169.745n 0.0v 169.755n 1.0v 174.745n 1.0v 174.755n 0.0v 179.745n 0.0v 179.755n 1.0v 184.745n 1.0v 184.755n 0.0v 189.745n 0.0v 189.755n 0.0v 194.745n 0.0v 194.755n 1.0v 199.745n 1.0v 199.755n 0.0v 204.745n 0.0v 204.755n 0.0v 209.745n 0.0v 209.755n 0.0v 214.745n 0.0v 214.755n 0.0v 219.745n 0.0v 219.755n 0.0v 224.745n 0.0v 224.755n 1.0v 229.745n 1.0v 229.755n 0.0v 234.745n 0.0v 234.755n 0.0v 239.745n 0.0v 239.755n 0.0v 244.745n 0.0v 244.755n 0.0v 249.745n 0.0v 249.755n 1.0v 254.745n 1.0v 254.755n 0.0v 259.745n 0.0v 259.755n 0.0v 264.745n 0.0v 264.755n 1.0v 269.745n 1.0v 269.755n 0.0v 274.745n 0.0v 274.755n 0.0v 279.745n 0.0v 279.755n 0.0v 284.745n 0.0v 284.755n 0.0v 289.745n 0.0v 289.755n 1.0v 294.745n 1.0v 294.755n 0.0v 299.745n 0.0v 299.755n 0.0v 304.745n 0.0v 304.755n 0.0v 309.745n 0.0v 309.755n 0.0v 314.745n 0.0v 314.755n 0.0v 319.745n 0.0v 319.755n 0.0v 324.745n 0.0v 324.755n 0.0v 329.745n 0.0v 329.755n 1.0v 334.745n 1.0v 334.755n 0.0v 339.745n 0.0v 339.755n 0.0v 344.745n 0.0v 344.755n 0.0v 349.745n 0.0v 349.755n 0.0v 354.745n 0.0v 354.755n 1.0v 359.745n 1.0v 359.755n 1.0v 364.745n 1.0v 364.755n 0.0v 369.745n 0.0v 369.755n 0.0v 374.745n 0.0v 374.755n 1.0v 379.745n 1.0v 379.755n 0.0v 384.745n 0.0v 384.755n 0.0v 389.745n 0.0v 389.755n 0.0v 394.745n 0.0v 394.755n 0.0v 399.745n 0.0v 399.755n 1.0v 404.745n 1.0v 404.755n 0.0v 409.745n 0.0v 409.755n 0.0v 414.745n 0.0v 414.755n 1.0v 419.745n 1.0v 419.755n 0.0v 424.745n 0.0v 424.755n 0.0v 429.745n 0.0v 429.755n 0.0v 434.745n 0.0v 434.755n 0.0v 439.745n 0.0v 439.755n 0.0v 444.745n 0.0v 444.755n 0.0v 449.745n 0.0v 449.755n 0.0v 454.745n 0.0v 454.755n 0.0v 459.745n 0.0v 459.755n 0.0v 464.745n 0.0v 464.755n 1.0v 469.745n 1.0v 469.755n 0.0v 474.745n 0.0v 474.755n 0.0v 479.745n 0.0v 479.755n 0.0v 484.745n 0.0v 484.755n 0.0v 489.745n 0.0v 489.755n 1.0v 494.745n 1.0v 494.755n 0.0v 499.745n 0.0v 499.755n 0.0v 504.745n 0.0v 504.755n 0.0v 509.745n 0.0v 509.755n 1.0v 514.745n 1.0v 514.755n 0.0v 519.745n 0.0v 519.755n 0.0v 524.745n 0.0v 524.755n 0.0v 529.745n 0.0v 529.755n 0.0v 534.745n 0.0v 534.755n 0.0v 539.745n 0.0v 539.755n 1.0v 544.745n 1.0v 544.755n 0.0v 549.745n 0.0v 549.755n 0.0v 554.745n 0.0v 554.755n 1.0v 559.745n 1.0v 559.755n 0.0v 564.745n 0.0v 564.755n 1.0v 569.745n 1.0v 569.755n 0.0v 574.745n 0.0v 574.755n 0.0v 579.745n 0.0v 579.755n 0.0v 584.745n 0.0v 584.755n 0.0v 589.745n 0.0v 589.755n 1.0v 594.745n 1.0v 594.755n 0.0v 599.745n 0.0v 599.755n 1.0v 604.745n 1.0v 604.755n 0.0v 609.745n 0.0v 609.755n 0.0v 614.745n 0.0v 614.755n 0.0v 619.745n 0.0v 619.755n 1.0v 624.745n 1.0v 624.755n 0.0v 629.745n 0.0v 629.755n 0.0v 634.745n 0.0v 634.755n 0.0v 639.745n 0.0v 639.755n 0.0v 644.745n 0.0v 644.755n 0.0v 649.745n 0.0v 649.755n 1.0v 654.745n 1.0v 654.755n 0.0v 659.745n 0.0v 659.755n 0.0v 664.745n 0.0v 664.755n 0.0v 669.745n 0.0v 669.755n 1.0v 674.745n 1.0v 674.755n 0.0v 679.745n 0.0v 679.755n 0.0v 684.745n 0.0v 684.755n 0.0v 689.745n 0.0v 689.755n 1.0v 694.745n 1.0v 694.755n 0.0v 699.745n 0.0v 699.755n 0.0v 704.745n 0.0v 704.755n 1.0v 709.745n 1.0v 709.755n 0.0v 714.745n 0.0v 714.755n 0.0v 719.745n 0.0v 719.755n 0.0v 724.745n 0.0v 724.755n 0.0v 729.745n 0.0v 729.755n 0.0v 734.745n 0.0v 734.755n 1.0v 739.745n 1.0v 739.755n 1.0v 744.745n 1.0v 744.755n 1.0v 749.745n 1.0v 749.755n 0.0v 754.745n 0.0v 754.755n 1.0v 759.745n 1.0v 759.755n 0.0v 764.745n 0.0v 764.755n 0.0v 769.745n 0.0v 769.755n 1.0v 774.745n 1.0v 774.755n 0.0v 779.745n 0.0v 779.755n 0.0v 784.745n 0.0v 784.755n 0.0v 789.745n 0.0v 789.755n 0.0v 794.745n 0.0v 794.755n 0.0v 799.745n 0.0v 799.755n 0.0v 804.745n 0.0v 804.755n 0.0v 809.745n 0.0v 809.755n 0.0v 814.745n 0.0v 814.755n 0.0v 819.745n 0.0v 819.755n 0.0v 824.745n 0.0v 824.755n 1.0v 829.745n 1.0v 829.755n 1.0v 834.745n 1.0v 834.755n 0.0v 839.745n 0.0v 839.755n 0.0v 844.745n 0.0v 844.755n 0.0v 849.745n 0.0v 849.755n 1.0v 854.745n 1.0v 854.755n 0.0v 859.745n 0.0v 859.755n 0.0v 864.745n 0.0v 864.755n 0.0v 869.745n 0.0v 869.755n 0.0v 874.745n 0.0v 874.755n 0.0v 879.745n 0.0v 879.755n 0.0v 884.745n 0.0v 884.755n 1.0v 889.745n 1.0v 889.755n 1.0v 894.745n 1.0v 894.755n 0.0v 899.745n 0.0v 899.755n 0.0v 904.745n 0.0v 904.755n 0.0v 909.745n 0.0v 909.755n 0.0v 914.745n 0.0v 914.755n 0.0v 919.745n 0.0v 919.755n 0.0v 924.745n 0.0v 924.755n 0.0v 929.745n 0.0v 929.755n 0.0v 934.745n 0.0v 934.755n 0.0v 939.745n 0.0v 939.755n 1.0v 944.745n 1.0v 944.755n 0.0v 949.745n 0.0v 949.755n 1.0v 954.745n 1.0v 954.755n 0.0v 959.745n 0.0v 959.755n 0.0v 964.745n 0.0v 964.755n 0.0v 969.745n 0.0v 969.755n 0.0v 974.745n 0.0v 974.755n 0.0v 979.745n 0.0v 979.755n 0.0v 984.745n 0.0v 984.755n 0.0v 989.745n 0.0v 989.755n 1.0v 994.745n 1.0v 994.755n 0.0v 999.745n 0.0v 999.755n 1.0v 1004.745n 1.0v 1004.755n 0.0v 1009.745n 0.0v 1009.755n 1.0v 1014.745n 1.0v 1014.755n 0.0v 1019.745n 0.0v 1019.755n 1.0v 1024.745n 1.0v 1024.755n 1.0v )
* (time, data): [(0, 1), (5, 0), (10, 0), (15, 0), (20, 1), (25, 1), (30, 1), (35, 1), (40, 1), (45, 1), (50, 1), (55, 0), (60, 0), (65, 1), (70, 0), (75, 0), (80, 1), (85, 1), (90, 1), (95, 0), (100, 1), (105, 1), (110, 1), (115, 1), (120, 0), (125, 1), (130, 1), (135, 0), (140, 0), (145, 1), (150, 1), (155, 1), (160, 1), (165, 1), (170, 1), (175, 1), (180, 1), (185, 1), (190, 1), (195, 1), (200, 0), (205, 0), (210, 1), (215, 1), (220, 1), (225, 1), (230, 1), (235, 1), (240, 1), (245, 1), (250, 1), (255, 0), (260, 0), (265, 1), (270, 1), (275, 0), (280, 1), (285, 0), (290, 1), (295, 1), (300, 1), (305, 1), (310, 1), (315, 1), (320, 0), (325, 1), (330, 1), (335, 1), (340, 1), (345, 0), (350, 0), (355, 1), (360, 1), (365, 1), (370, 1), (375, 1), (380, 1), (385, 1), (390, 1), (395, 0), (400, 1), (405, 1), (410, 0), (415, 1), (420, 1), (425, 1), (430, 1), (435, 1), (440, 1), (445, 0), (450, 0), (455, 0), (460, 1), (465, 1), (470, 0), (475, 0), (480, 1), (485, 1), (490, 1), (495, 1), (500, 1), (505, 1), (510, 1), (515, 1), (520, 0), (525, 1), (530, 1), (535, 1), (540, 1), (545, 1), (550, 1), (555, 1), (560, 1), (565, 1), (570, 1), (575, 0), (580, 1), (585, 1), (590, 1), (595, 0), (600, 1), (605, 1), (610, 1), (615, 1), (620, 1), (625, 0), (630, 0), (635, 1), (640, 0), (645, 1), (650, 1), (655, 0), (660, 1), (665, 0), (670, 1), (675, 0), (680, 0), (685, 1), (690, 1), (695, 0), (700, 1), (705, 1), (710, 1), (715, 0), (720, 1), (725, 1), (730, 1), (735, 1), (740, 1), (745, 1), (750, 0), (755, 1), (760, 1), (765, 1), (770, 1), (775, 0), (780, 1), (785, 1), (790, 0), (795, 0), (800, 0), (805, 1), (810, 1), (815, 1), (820, 0), (825, 1), (830, 1), (835, 1), (840, 1), (845, 1), (850, 1), (855, 0), (860, 1), (865, 1), (870, 1), (875, 1), (880, 1), (885, 1), (890, 1), (895, 0), (900, 1), (905, 0), (910, 1), (915, 0), (920, 0), (925, 1), (930, 0), (935, 1), (940, 1), (945, 1), (950, 1), (955, 1), (960, 0), (965, 0), (970, 1), (975, 1), (980, 1), (985, 1), (990, 1), (995, 1), (1000, 1), (1005, 1), (1010, 1), (1015, 0), (1020, 1), (1025, 1)]
VWEB0 WEB0 0 PWL (0n 1.0v 4.745n 1.0v 4.755n 0.0v 9.745n 0.0v 9.755n 0.0v 14.745n 0.0v 14.755n 0.0v 19.745n 0.0v 19.755n 1.0v 24.745n 1.0v 24.755n 1.0v 29.745n 1.0v 29.755n 1.0v 34.745n 1.0v 34.755n 1.0v 39.745n 1.0v 39.755n 1.0v 44.745n 1.0v 44.755n 1.0v 49.745n 1.0v 49.755n 1.0v 54.745n 1.0v 54.755n 0.0v 59.745n 0.0v 59.755n 0.0v 64.745n 0.0v 64.755n 1.0v 69.745n 1.0v 69.755n 0.0v 74.745n 0.0v 74.755n 0.0v 79.745n 0.0v 79.755n 1.0v 84.745n 1.0v 84.755n 1.0v 89.745n 1.0v 89.755n 1.0v 94.745n 1.0v 94.755n 0.0v 99.745n 0.0v 99.755n 1.0v 104.745n 1.0v 104.755n 1.0v 109.745n 1.0v 109.755n 1.0v 114.745n 1.0v 114.755n 1.0v 119.745n 1.0v 119.755n 0.0v 124.745n 0.0v 124.755n 1.0v 129.745n 1.0v 129.755n 1.0v 134.745n 1.0v 134.755n 0.0v 139.745n 0.0v 139.755n 0.0v 144.745n 0.0v 144.755n 1.0v 149.745n 1.0v 149.755n 1.0v 154.745n 1.0v 154.755n 1.0v 159.745n 1.0v 159.755n 1.0v 164.745n 1.0v 164.755n 1.0v 169.745n 1.0v 169.755n 1.0v 174.745n 1.0v 174.755n 1.0v 179.745n 1.0v 179.755n 1.0v 184.745n 1.0v 184.755n 1.0v 189.745n 1.0v 189.755n 1.0v 194.745n 1.0v 194.755n 1.0v 199.745n 1.0v 199.755n 0.0v 204.745n 0.0v 204.755n 0.0v 209.745n 0.0v 209.755n 1.0v 214.745n 1.0v 214.755n 1.0v 219.745n 1.0v 219.755n 1.0v 224.745n 1.0v 224.755n 1.0v 229.745n 1.0v 229.755n 1.0v 234.745n 1.0v 234.755n 1.0v 239.745n 1.0v 239.755n 1.0v 244.745n 1.0v 244.755n 1.0v 249.745n 1.0v 249.755n 1.0v 254.745n 1.0v 254.755n 0.0v 259.745n 0.0v 259.755n 0.0v 264.745n 0.0v 264.755n 1.0v 269.745n 1.0v 269.755n 1.0v 274.745n 1.0v 274.755n 0.0v 279.745n 0.0v 279.755n 1.0v 284.745n 1.0v 284.755n 0.0v 289.745n 0.0v 289.755n 1.0v 294.745n 1.0v 294.755n 1.0v 299.745n 1.0v 299.755n 1.0v 304.745n 1.0v 304.755n 1.0v 309.745n 1.0v 309.755n 1.0v 314.745n 1.0v 314.755n 1.0v 319.745n 1.0v 319.755n 0.0v 324.745n 0.0v 324.755n 1.0v 329.745n 1.0v 329.755n 1.0v 334.745n 1.0v 334.755n 1.0v 339.745n 1.0v 339.755n 1.0v 344.745n 1.0v 344.755n 0.0v 349.745n 0.0v 349.755n 0.0v 354.745n 0.0v 354.755n 1.0v 359.745n 1.0v 359.755n 1.0v 364.745n 1.0v 364.755n 1.0v 369.745n 1.0v 369.755n 1.0v 374.745n 1.0v 374.755n 1.0v 379.745n 1.0v 379.755n 1.0v 384.745n 1.0v 384.755n 1.0v 389.745n 1.0v 389.755n 1.0v 394.745n 1.0v 394.755n 0.0v 399.745n 0.0v 399.755n 1.0v 404.745n 1.0v 404.755n 1.0v 409.745n 1.0v 409.755n 0.0v 414.745n 0.0v 414.755n 1.0v 419.745n 1.0v 419.755n 1.0v 424.745n 1.0v 424.755n 1.0v 429.745n 1.0v 429.755n 1.0v 434.745n 1.0v 434.755n 1.0v 439.745n 1.0v 439.755n 1.0v 444.745n 1.0v 444.755n 0.0v 449.745n 0.0v 449.755n 0.0v 454.745n 0.0v 454.755n 0.0v 459.745n 0.0v 459.755n 1.0v 464.745n 1.0v 464.755n 1.0v 469.745n 1.0v 469.755n 0.0v 474.745n 0.0v 474.755n 0.0v 479.745n 0.0v 479.755n 1.0v 484.745n 1.0v 484.755n 1.0v 489.745n 1.0v 489.755n 1.0v 494.745n 1.0v 494.755n 1.0v 499.745n 1.0v 499.755n 1.0v 504.745n 1.0v 504.755n 1.0v 509.745n 1.0v 509.755n 1.0v 514.745n 1.0v 514.755n 1.0v 519.745n 1.0v 519.755n 0.0v 524.745n 0.0v 524.755n 1.0v 529.745n 1.0v 529.755n 1.0v 534.745n 1.0v 534.755n 1.0v 539.745n 1.0v 539.755n 1.0v 544.745n 1.0v 544.755n 1.0v 549.745n 1.0v 549.755n 1.0v 554.745n 1.0v 554.755n 1.0v 559.745n 1.0v 559.755n 1.0v 564.745n 1.0v 564.755n 1.0v 569.745n 1.0v 569.755n 1.0v 574.745n 1.0v 574.755n 0.0v 579.745n 0.0v 579.755n 1.0v 584.745n 1.0v 584.755n 1.0v 589.745n 1.0v 589.755n 1.0v 594.745n 1.0v 594.755n 0.0v 599.745n 0.0v 599.755n 1.0v 604.745n 1.0v 604.755n 1.0v 609.745n 1.0v 609.755n 1.0v 614.745n 1.0v 614.755n 1.0v 619.745n 1.0v 619.755n 1.0v 624.745n 1.0v 624.755n 0.0v 629.745n 0.0v 629.755n 0.0v 634.745n 0.0v 634.755n 1.0v 639.745n 1.0v 639.755n 0.0v 644.745n 0.0v 644.755n 1.0v 649.745n 1.0v 649.755n 1.0v 654.745n 1.0v 654.755n 0.0v 659.745n 0.0v 659.755n 1.0v 664.745n 1.0v 664.755n 0.0v 669.745n 0.0v 669.755n 1.0v 674.745n 1.0v 674.755n 0.0v 679.745n 0.0v 679.755n 0.0v 684.745n 0.0v 684.755n 1.0v 689.745n 1.0v 689.755n 1.0v 694.745n 1.0v 694.755n 0.0v 699.745n 0.0v 699.755n 1.0v 704.745n 1.0v 704.755n 1.0v 709.745n 1.0v 709.755n 1.0v 714.745n 1.0v 714.755n 0.0v 719.745n 0.0v 719.755n 1.0v 724.745n 1.0v 724.755n 1.0v 729.745n 1.0v 729.755n 1.0v 734.745n 1.0v 734.755n 1.0v 739.745n 1.0v 739.755n 1.0v 744.745n 1.0v 744.755n 1.0v 749.745n 1.0v 749.755n 0.0v 754.745n 0.0v 754.755n 1.0v 759.745n 1.0v 759.755n 1.0v 764.745n 1.0v 764.755n 1.0v 769.745n 1.0v 769.755n 1.0v 774.745n 1.0v 774.755n 0.0v 779.745n 0.0v 779.755n 1.0v 784.745n 1.0v 784.755n 1.0v 789.745n 1.0v 789.755n 0.0v 794.745n 0.0v 794.755n 0.0v 799.745n 0.0v 799.755n 0.0v 804.745n 0.0v 804.755n 1.0v 809.745n 1.0v 809.755n 1.0v 814.745n 1.0v 814.755n 1.0v 819.745n 1.0v 819.755n 0.0v 824.745n 0.0v 824.755n 1.0v 829.745n 1.0v 829.755n 1.0v 834.745n 1.0v 834.755n 1.0v 839.745n 1.0v 839.755n 1.0v 844.745n 1.0v 844.755n 1.0v 849.745n 1.0v 849.755n 1.0v 854.745n 1.0v 854.755n 0.0v 859.745n 0.0v 859.755n 1.0v 864.745n 1.0v 864.755n 1.0v 869.745n 1.0v 869.755n 1.0v 874.745n 1.0v 874.755n 1.0v 879.745n 1.0v 879.755n 1.0v 884.745n 1.0v 884.755n 1.0v 889.745n 1.0v 889.755n 1.0v 894.745n 1.0v 894.755n 0.0v 899.745n 0.0v 899.755n 1.0v 904.745n 1.0v 904.755n 0.0v 909.745n 0.0v 909.755n 1.0v 914.745n 1.0v 914.755n 0.0v 919.745n 0.0v 919.755n 0.0v 924.745n 0.0v 924.755n 1.0v 929.745n 1.0v 929.755n 0.0v 934.745n 0.0v 934.755n 1.0v 939.745n 1.0v 939.755n 1.0v 944.745n 1.0v 944.755n 1.0v 949.745n 1.0v 949.755n 1.0v 954.745n 1.0v 954.755n 1.0v 959.745n 1.0v 959.755n 0.0v 964.745n 0.0v 964.755n 0.0v 969.745n 0.0v 969.755n 1.0v 974.745n 1.0v 974.755n 1.0v 979.745n 1.0v 979.755n 1.0v 984.745n 1.0v 984.755n 1.0v 989.745n 1.0v 989.755n 1.0v 994.745n 1.0v 994.755n 1.0v 999.745n 1.0v 999.755n 1.0v 1004.745n 1.0v 1004.755n 1.0v 1009.745n 1.0v 1009.755n 1.0v 1014.745n 1.0v 1014.755n 0.0v 1019.745n 0.0v 1019.755n 1.0v 1024.745n 1.0v 1024.755n 1.0v )
* PULSE: period=5
Vclk0 clk0 0 PULSE (0 1.0 4.995n 0.01n 0.01n 2.49n 5n)

 * Generation of dout measurements
* CHECK dout0_0 Vdout0_0ck4 = 1.0 time = 25
.meas tran vdout0_0ck4 FIND v(dout0_0) AT=25.025n

* CHECK dout0_1 Vdout0_1ck4 = 0 time = 25
.meas tran vdout0_1ck4 FIND v(dout0_1) AT=25.025n

* CHECK dout0_2 Vdout0_2ck4 = 1.0 time = 25
.meas tran vdout0_2ck4 FIND v(dout0_2) AT=25.025n

* CHECK dout0_3 Vdout0_3ck4 = 1.0 time = 25
.meas tran vdout0_3ck4 FIND v(dout0_3) AT=25.025n

* CHECK dout0_4 Vdout0_4ck4 = 1.0 time = 25
.meas tran vdout0_4ck4 FIND v(dout0_4) AT=25.025n

* CHECK dout0_5 Vdout0_5ck4 = 1.0 time = 25
.meas tran vdout0_5ck4 FIND v(dout0_5) AT=25.025n

* CHECK dout0_6 Vdout0_6ck4 = 1.0 time = 25
.meas tran vdout0_6ck4 FIND v(dout0_6) AT=25.025n

* CHECK dout0_7 Vdout0_7ck4 = 0 time = 25
.meas tran vdout0_7ck4 FIND v(dout0_7) AT=25.025n

* CHECK dout0_0 Vdout0_0ck5 = 1.0 time = 30
.meas tran vdout0_0ck5 FIND v(dout0_0) AT=30.025n

* CHECK dout0_1 Vdout0_1ck5 = 0 time = 30
.meas tran vdout0_1ck5 FIND v(dout0_1) AT=30.025n

* CHECK dout0_2 Vdout0_2ck5 = 1.0 time = 30
.meas tran vdout0_2ck5 FIND v(dout0_2) AT=30.025n

* CHECK dout0_3 Vdout0_3ck5 = 1.0 time = 30
.meas tran vdout0_3ck5 FIND v(dout0_3) AT=30.025n

* CHECK dout0_4 Vdout0_4ck5 = 1.0 time = 30
.meas tran vdout0_4ck5 FIND v(dout0_4) AT=30.025n

* CHECK dout0_5 Vdout0_5ck5 = 1.0 time = 30
.meas tran vdout0_5ck5 FIND v(dout0_5) AT=30.025n

* CHECK dout0_6 Vdout0_6ck5 = 1.0 time = 30
.meas tran vdout0_6ck5 FIND v(dout0_6) AT=30.025n

* CHECK dout0_7 Vdout0_7ck5 = 0 time = 30
.meas tran vdout0_7ck5 FIND v(dout0_7) AT=30.025n

* CHECK dout0_0 Vdout0_0ck7 = 1.0 time = 40
.meas tran vdout0_0ck7 FIND v(dout0_0) AT=40.025n

* CHECK dout0_1 Vdout0_1ck7 = 1.0 time = 40
.meas tran vdout0_1ck7 FIND v(dout0_1) AT=40.025n

* CHECK dout0_2 Vdout0_2ck7 = 1.0 time = 40
.meas tran vdout0_2ck7 FIND v(dout0_2) AT=40.025n

* CHECK dout0_3 Vdout0_3ck7 = 1.0 time = 40
.meas tran vdout0_3ck7 FIND v(dout0_3) AT=40.025n

* CHECK dout0_4 Vdout0_4ck7 = 0 time = 40
.meas tran vdout0_4ck7 FIND v(dout0_4) AT=40.025n

* CHECK dout0_5 Vdout0_5ck7 = 0 time = 40
.meas tran vdout0_5ck7 FIND v(dout0_5) AT=40.025n

* CHECK dout0_6 Vdout0_6ck7 = 0 time = 40
.meas tran vdout0_6ck7 FIND v(dout0_6) AT=40.025n

* CHECK dout0_7 Vdout0_7ck7 = 1.0 time = 40
.meas tran vdout0_7ck7 FIND v(dout0_7) AT=40.025n

* CHECK dout0_0 Vdout0_0ck8 = 0 time = 45
.meas tran vdout0_0ck8 FIND v(dout0_0) AT=45.025n

* CHECK dout0_1 Vdout0_1ck8 = 0 time = 45
.meas tran vdout0_1ck8 FIND v(dout0_1) AT=45.025n

* CHECK dout0_2 Vdout0_2ck8 = 0 time = 45
.meas tran vdout0_2ck8 FIND v(dout0_2) AT=45.025n

* CHECK dout0_3 Vdout0_3ck8 = 0 time = 45
.meas tran vdout0_3ck8 FIND v(dout0_3) AT=45.025n

* CHECK dout0_4 Vdout0_4ck8 = 0 time = 45
.meas tran vdout0_4ck8 FIND v(dout0_4) AT=45.025n

* CHECK dout0_5 Vdout0_5ck8 = 0 time = 45
.meas tran vdout0_5ck8 FIND v(dout0_5) AT=45.025n

* CHECK dout0_6 Vdout0_6ck8 = 1.0 time = 45
.meas tran vdout0_6ck8 FIND v(dout0_6) AT=45.025n

* CHECK dout0_7 Vdout0_7ck8 = 0 time = 45
.meas tran vdout0_7ck8 FIND v(dout0_7) AT=45.025n

* CHECK dout0_0 Vdout0_0ck9 = 0 time = 50
.meas tran vdout0_0ck9 FIND v(dout0_0) AT=50.025n

* CHECK dout0_1 Vdout0_1ck9 = 0 time = 50
.meas tran vdout0_1ck9 FIND v(dout0_1) AT=50.025n

* CHECK dout0_2 Vdout0_2ck9 = 0 time = 50
.meas tran vdout0_2ck9 FIND v(dout0_2) AT=50.025n

* CHECK dout0_3 Vdout0_3ck9 = 0 time = 50
.meas tran vdout0_3ck9 FIND v(dout0_3) AT=50.025n

* CHECK dout0_4 Vdout0_4ck9 = 0 time = 50
.meas tran vdout0_4ck9 FIND v(dout0_4) AT=50.025n

* CHECK dout0_5 Vdout0_5ck9 = 0 time = 50
.meas tran vdout0_5ck9 FIND v(dout0_5) AT=50.025n

* CHECK dout0_6 Vdout0_6ck9 = 1.0 time = 50
.meas tran vdout0_6ck9 FIND v(dout0_6) AT=50.025n

* CHECK dout0_7 Vdout0_7ck9 = 0 time = 50
.meas tran vdout0_7ck9 FIND v(dout0_7) AT=50.025n

* CHECK dout0_0 Vdout0_0ck16 = 1.0 time = 85
.meas tran vdout0_0ck16 FIND v(dout0_0) AT=85.025n

* CHECK dout0_1 Vdout0_1ck16 = 0 time = 85
.meas tran vdout0_1ck16 FIND v(dout0_1) AT=85.025n

* CHECK dout0_2 Vdout0_2ck16 = 0 time = 85
.meas tran vdout0_2ck16 FIND v(dout0_2) AT=85.025n

* CHECK dout0_3 Vdout0_3ck16 = 1.0 time = 85
.meas tran vdout0_3ck16 FIND v(dout0_3) AT=85.025n

* CHECK dout0_4 Vdout0_4ck16 = 1.0 time = 85
.meas tran vdout0_4ck16 FIND v(dout0_4) AT=85.025n

* CHECK dout0_5 Vdout0_5ck16 = 0 time = 85
.meas tran vdout0_5ck16 FIND v(dout0_5) AT=85.025n

* CHECK dout0_6 Vdout0_6ck16 = 1.0 time = 85
.meas tran vdout0_6ck16 FIND v(dout0_6) AT=85.025n

* CHECK dout0_7 Vdout0_7ck16 = 1.0 time = 85
.meas tran vdout0_7ck16 FIND v(dout0_7) AT=85.025n

* CHECK dout0_0 Vdout0_0ck17 = 1.0 time = 90
.meas tran vdout0_0ck17 FIND v(dout0_0) AT=90.025n

* CHECK dout0_1 Vdout0_1ck17 = 0 time = 90
.meas tran vdout0_1ck17 FIND v(dout0_1) AT=90.025n

* CHECK dout0_2 Vdout0_2ck17 = 1.0 time = 90
.meas tran vdout0_2ck17 FIND v(dout0_2) AT=90.025n

* CHECK dout0_3 Vdout0_3ck17 = 1.0 time = 90
.meas tran vdout0_3ck17 FIND v(dout0_3) AT=90.025n

* CHECK dout0_4 Vdout0_4ck17 = 1.0 time = 90
.meas tran vdout0_4ck17 FIND v(dout0_4) AT=90.025n

* CHECK dout0_5 Vdout0_5ck17 = 1.0 time = 90
.meas tran vdout0_5ck17 FIND v(dout0_5) AT=90.025n

* CHECK dout0_6 Vdout0_6ck17 = 1.0 time = 90
.meas tran vdout0_6ck17 FIND v(dout0_6) AT=90.025n

* CHECK dout0_7 Vdout0_7ck17 = 0 time = 90
.meas tran vdout0_7ck17 FIND v(dout0_7) AT=90.025n

* CHECK dout0_0 Vdout0_0ck20 = 0 time = 105
.meas tran vdout0_0ck20 FIND v(dout0_0) AT=105.025n

* CHECK dout0_1 Vdout0_1ck20 = 0 time = 105
.meas tran vdout0_1ck20 FIND v(dout0_1) AT=105.025n

* CHECK dout0_2 Vdout0_2ck20 = 0 time = 105
.meas tran vdout0_2ck20 FIND v(dout0_2) AT=105.025n

* CHECK dout0_3 Vdout0_3ck20 = 0 time = 105
.meas tran vdout0_3ck20 FIND v(dout0_3) AT=105.025n

* CHECK dout0_4 Vdout0_4ck20 = 0 time = 105
.meas tran vdout0_4ck20 FIND v(dout0_4) AT=105.025n

* CHECK dout0_5 Vdout0_5ck20 = 0 time = 105
.meas tran vdout0_5ck20 FIND v(dout0_5) AT=105.025n

* CHECK dout0_6 Vdout0_6ck20 = 1.0 time = 105
.meas tran vdout0_6ck20 FIND v(dout0_6) AT=105.025n

* CHECK dout0_7 Vdout0_7ck20 = 0 time = 105
.meas tran vdout0_7ck20 FIND v(dout0_7) AT=105.025n

* CHECK dout0_0 Vdout0_0ck21 = 1.0 time = 110
.meas tran vdout0_0ck21 FIND v(dout0_0) AT=110.025n

* CHECK dout0_1 Vdout0_1ck21 = 0 time = 110
.meas tran vdout0_1ck21 FIND v(dout0_1) AT=110.025n

* CHECK dout0_2 Vdout0_2ck21 = 1.0 time = 110
.meas tran vdout0_2ck21 FIND v(dout0_2) AT=110.025n

* CHECK dout0_3 Vdout0_3ck21 = 1.0 time = 110
.meas tran vdout0_3ck21 FIND v(dout0_3) AT=110.025n

* CHECK dout0_4 Vdout0_4ck21 = 1.0 time = 110
.meas tran vdout0_4ck21 FIND v(dout0_4) AT=110.025n

* CHECK dout0_5 Vdout0_5ck21 = 1.0 time = 110
.meas tran vdout0_5ck21 FIND v(dout0_5) AT=110.025n

* CHECK dout0_6 Vdout0_6ck21 = 1.0 time = 110
.meas tran vdout0_6ck21 FIND v(dout0_6) AT=110.025n

* CHECK dout0_7 Vdout0_7ck21 = 0 time = 110
.meas tran vdout0_7ck21 FIND v(dout0_7) AT=110.025n

* CHECK dout0_0 Vdout0_0ck22 = 1.0 time = 115
.meas tran vdout0_0ck22 FIND v(dout0_0) AT=115.025n

* CHECK dout0_1 Vdout0_1ck22 = 1.0 time = 115
.meas tran vdout0_1ck22 FIND v(dout0_1) AT=115.025n

* CHECK dout0_2 Vdout0_2ck22 = 0 time = 115
.meas tran vdout0_2ck22 FIND v(dout0_2) AT=115.025n

* CHECK dout0_3 Vdout0_3ck22 = 1.0 time = 115
.meas tran vdout0_3ck22 FIND v(dout0_3) AT=115.025n

* CHECK dout0_4 Vdout0_4ck22 = 0 time = 115
.meas tran vdout0_4ck22 FIND v(dout0_4) AT=115.025n

* CHECK dout0_5 Vdout0_5ck22 = 1.0 time = 115
.meas tran vdout0_5ck22 FIND v(dout0_5) AT=115.025n

* CHECK dout0_6 Vdout0_6ck22 = 0 time = 115
.meas tran vdout0_6ck22 FIND v(dout0_6) AT=115.025n

* CHECK dout0_7 Vdout0_7ck22 = 0 time = 115
.meas tran vdout0_7ck22 FIND v(dout0_7) AT=115.025n

* CHECK dout0_0 Vdout0_0ck23 = 1.0 time = 120
.meas tran vdout0_0ck23 FIND v(dout0_0) AT=120.025n

* CHECK dout0_1 Vdout0_1ck23 = 0 time = 120
.meas tran vdout0_1ck23 FIND v(dout0_1) AT=120.025n

* CHECK dout0_2 Vdout0_2ck23 = 0 time = 120
.meas tran vdout0_2ck23 FIND v(dout0_2) AT=120.025n

* CHECK dout0_3 Vdout0_3ck23 = 0 time = 120
.meas tran vdout0_3ck23 FIND v(dout0_3) AT=120.025n

* CHECK dout0_4 Vdout0_4ck23 = 0 time = 120
.meas tran vdout0_4ck23 FIND v(dout0_4) AT=120.025n

* CHECK dout0_5 Vdout0_5ck23 = 1.0 time = 120
.meas tran vdout0_5ck23 FIND v(dout0_5) AT=120.025n

* CHECK dout0_6 Vdout0_6ck23 = 1.0 time = 120
.meas tran vdout0_6ck23 FIND v(dout0_6) AT=120.025n

* CHECK dout0_7 Vdout0_7ck23 = 0 time = 120
.meas tran vdout0_7ck23 FIND v(dout0_7) AT=120.025n

* CHECK dout0_0 Vdout0_0ck25 = 0 time = 130
.meas tran vdout0_0ck25 FIND v(dout0_0) AT=130.025n

* CHECK dout0_1 Vdout0_1ck25 = 0 time = 130
.meas tran vdout0_1ck25 FIND v(dout0_1) AT=130.025n

* CHECK dout0_2 Vdout0_2ck25 = 0 time = 130
.meas tran vdout0_2ck25 FIND v(dout0_2) AT=130.025n

* CHECK dout0_3 Vdout0_3ck25 = 0 time = 130
.meas tran vdout0_3ck25 FIND v(dout0_3) AT=130.025n

* CHECK dout0_4 Vdout0_4ck25 = 0 time = 130
.meas tran vdout0_4ck25 FIND v(dout0_4) AT=130.025n

* CHECK dout0_5 Vdout0_5ck25 = 0 time = 130
.meas tran vdout0_5ck25 FIND v(dout0_5) AT=130.025n

* CHECK dout0_6 Vdout0_6ck25 = 1.0 time = 130
.meas tran vdout0_6ck25 FIND v(dout0_6) AT=130.025n

* CHECK dout0_7 Vdout0_7ck25 = 0 time = 130
.meas tran vdout0_7ck25 FIND v(dout0_7) AT=130.025n

* CHECK dout0_0 Vdout0_0ck26 = 1.0 time = 135
.meas tran vdout0_0ck26 FIND v(dout0_0) AT=135.025n

* CHECK dout0_1 Vdout0_1ck26 = 1.0 time = 135
.meas tran vdout0_1ck26 FIND v(dout0_1) AT=135.025n

* CHECK dout0_2 Vdout0_2ck26 = 0 time = 135
.meas tran vdout0_2ck26 FIND v(dout0_2) AT=135.025n

* CHECK dout0_3 Vdout0_3ck26 = 1.0 time = 135
.meas tran vdout0_3ck26 FIND v(dout0_3) AT=135.025n

* CHECK dout0_4 Vdout0_4ck26 = 0 time = 135
.meas tran vdout0_4ck26 FIND v(dout0_4) AT=135.025n

* CHECK dout0_5 Vdout0_5ck26 = 1.0 time = 135
.meas tran vdout0_5ck26 FIND v(dout0_5) AT=135.025n

* CHECK dout0_6 Vdout0_6ck26 = 0 time = 135
.meas tran vdout0_6ck26 FIND v(dout0_6) AT=135.025n

* CHECK dout0_7 Vdout0_7ck26 = 1.0 time = 135
.meas tran vdout0_7ck26 FIND v(dout0_7) AT=135.025n

* CHECK dout0_0 Vdout0_0ck29 = 0 time = 150
.meas tran vdout0_0ck29 FIND v(dout0_0) AT=150.025n

* CHECK dout0_1 Vdout0_1ck29 = 1.0 time = 150
.meas tran vdout0_1ck29 FIND v(dout0_1) AT=150.025n

* CHECK dout0_2 Vdout0_2ck29 = 1.0 time = 150
.meas tran vdout0_2ck29 FIND v(dout0_2) AT=150.025n

* CHECK dout0_3 Vdout0_3ck29 = 1.0 time = 150
.meas tran vdout0_3ck29 FIND v(dout0_3) AT=150.025n

* CHECK dout0_4 Vdout0_4ck29 = 1.0 time = 150
.meas tran vdout0_4ck29 FIND v(dout0_4) AT=150.025n

* CHECK dout0_5 Vdout0_5ck29 = 1.0 time = 150
.meas tran vdout0_5ck29 FIND v(dout0_5) AT=150.025n

* CHECK dout0_6 Vdout0_6ck29 = 0 time = 150
.meas tran vdout0_6ck29 FIND v(dout0_6) AT=150.025n

* CHECK dout0_7 Vdout0_7ck29 = 0 time = 150
.meas tran vdout0_7ck29 FIND v(dout0_7) AT=150.025n

* CHECK dout0_0 Vdout0_0ck30 = 0 time = 155
.meas tran vdout0_0ck30 FIND v(dout0_0) AT=155.025n

* CHECK dout0_1 Vdout0_1ck30 = 0 time = 155
.meas tran vdout0_1ck30 FIND v(dout0_1) AT=155.025n

* CHECK dout0_2 Vdout0_2ck30 = 0 time = 155
.meas tran vdout0_2ck30 FIND v(dout0_2) AT=155.025n

* CHECK dout0_3 Vdout0_3ck30 = 0 time = 155
.meas tran vdout0_3ck30 FIND v(dout0_3) AT=155.025n

* CHECK dout0_4 Vdout0_4ck30 = 0 time = 155
.meas tran vdout0_4ck30 FIND v(dout0_4) AT=155.025n

* CHECK dout0_5 Vdout0_5ck30 = 0 time = 155
.meas tran vdout0_5ck30 FIND v(dout0_5) AT=155.025n

* CHECK dout0_6 Vdout0_6ck30 = 1.0 time = 155
.meas tran vdout0_6ck30 FIND v(dout0_6) AT=155.025n

* CHECK dout0_7 Vdout0_7ck30 = 0 time = 155
.meas tran vdout0_7ck30 FIND v(dout0_7) AT=155.025n

* CHECK dout0_0 Vdout0_0ck31 = 0 time = 160
.meas tran vdout0_0ck31 FIND v(dout0_0) AT=160.025n

* CHECK dout0_1 Vdout0_1ck31 = 0 time = 160
.meas tran vdout0_1ck31 FIND v(dout0_1) AT=160.025n

* CHECK dout0_2 Vdout0_2ck31 = 0 time = 160
.meas tran vdout0_2ck31 FIND v(dout0_2) AT=160.025n

* CHECK dout0_3 Vdout0_3ck31 = 0 time = 160
.meas tran vdout0_3ck31 FIND v(dout0_3) AT=160.025n

* CHECK dout0_4 Vdout0_4ck31 = 0 time = 160
.meas tran vdout0_4ck31 FIND v(dout0_4) AT=160.025n

* CHECK dout0_5 Vdout0_5ck31 = 0 time = 160
.meas tran vdout0_5ck31 FIND v(dout0_5) AT=160.025n

* CHECK dout0_6 Vdout0_6ck31 = 1.0 time = 160
.meas tran vdout0_6ck31 FIND v(dout0_6) AT=160.025n

* CHECK dout0_7 Vdout0_7ck31 = 0 time = 160
.meas tran vdout0_7ck31 FIND v(dout0_7) AT=160.025n

* CHECK dout0_0 Vdout0_0ck33 = 1.0 time = 170
.meas tran vdout0_0ck33 FIND v(dout0_0) AT=170.025n

* CHECK dout0_1 Vdout0_1ck33 = 1.0 time = 170
.meas tran vdout0_1ck33 FIND v(dout0_1) AT=170.025n

* CHECK dout0_2 Vdout0_2ck33 = 1.0 time = 170
.meas tran vdout0_2ck33 FIND v(dout0_2) AT=170.025n

* CHECK dout0_3 Vdout0_3ck33 = 1.0 time = 170
.meas tran vdout0_3ck33 FIND v(dout0_3) AT=170.025n

* CHECK dout0_4 Vdout0_4ck33 = 0 time = 170
.meas tran vdout0_4ck33 FIND v(dout0_4) AT=170.025n

* CHECK dout0_5 Vdout0_5ck33 = 0 time = 170
.meas tran vdout0_5ck33 FIND v(dout0_5) AT=170.025n

* CHECK dout0_6 Vdout0_6ck33 = 0 time = 170
.meas tran vdout0_6ck33 FIND v(dout0_6) AT=170.025n

* CHECK dout0_7 Vdout0_7ck33 = 1.0 time = 170
.meas tran vdout0_7ck33 FIND v(dout0_7) AT=170.025n

* CHECK dout0_0 Vdout0_0ck35 = 1.0 time = 180
.meas tran vdout0_0ck35 FIND v(dout0_0) AT=180.025n

* CHECK dout0_1 Vdout0_1ck35 = 1.0 time = 180
.meas tran vdout0_1ck35 FIND v(dout0_1) AT=180.025n

* CHECK dout0_2 Vdout0_2ck35 = 0 time = 180
.meas tran vdout0_2ck35 FIND v(dout0_2) AT=180.025n

* CHECK dout0_3 Vdout0_3ck35 = 1.0 time = 180
.meas tran vdout0_3ck35 FIND v(dout0_3) AT=180.025n

* CHECK dout0_4 Vdout0_4ck35 = 0 time = 180
.meas tran vdout0_4ck35 FIND v(dout0_4) AT=180.025n

* CHECK dout0_5 Vdout0_5ck35 = 1.0 time = 180
.meas tran vdout0_5ck35 FIND v(dout0_5) AT=180.025n

* CHECK dout0_6 Vdout0_6ck35 = 0 time = 180
.meas tran vdout0_6ck35 FIND v(dout0_6) AT=180.025n

* CHECK dout0_7 Vdout0_7ck35 = 0 time = 180
.meas tran vdout0_7ck35 FIND v(dout0_7) AT=180.025n

* CHECK dout0_0 Vdout0_0ck37 = 1.0 time = 190
.meas tran vdout0_0ck37 FIND v(dout0_0) AT=190.025n

* CHECK dout0_1 Vdout0_1ck37 = 0 time = 190
.meas tran vdout0_1ck37 FIND v(dout0_1) AT=190.025n

* CHECK dout0_2 Vdout0_2ck37 = 1.0 time = 190
.meas tran vdout0_2ck37 FIND v(dout0_2) AT=190.025n

* CHECK dout0_3 Vdout0_3ck37 = 1.0 time = 190
.meas tran vdout0_3ck37 FIND v(dout0_3) AT=190.025n

* CHECK dout0_4 Vdout0_4ck37 = 1.0 time = 190
.meas tran vdout0_4ck37 FIND v(dout0_4) AT=190.025n

* CHECK dout0_5 Vdout0_5ck37 = 1.0 time = 190
.meas tran vdout0_5ck37 FIND v(dout0_5) AT=190.025n

* CHECK dout0_6 Vdout0_6ck37 = 1.0 time = 190
.meas tran vdout0_6ck37 FIND v(dout0_6) AT=190.025n

* CHECK dout0_7 Vdout0_7ck37 = 0 time = 190
.meas tran vdout0_7ck37 FIND v(dout0_7) AT=190.025n

* CHECK dout0_0 Vdout0_0ck38 = 1.0 time = 195
.meas tran vdout0_0ck38 FIND v(dout0_0) AT=195.025n

* CHECK dout0_1 Vdout0_1ck38 = 1.0 time = 195
.meas tran vdout0_1ck38 FIND v(dout0_1) AT=195.025n

* CHECK dout0_2 Vdout0_2ck38 = 0 time = 195
.meas tran vdout0_2ck38 FIND v(dout0_2) AT=195.025n

* CHECK dout0_3 Vdout0_3ck38 = 1.0 time = 195
.meas tran vdout0_3ck38 FIND v(dout0_3) AT=195.025n

* CHECK dout0_4 Vdout0_4ck38 = 0 time = 195
.meas tran vdout0_4ck38 FIND v(dout0_4) AT=195.025n

* CHECK dout0_5 Vdout0_5ck38 = 1.0 time = 195
.meas tran vdout0_5ck38 FIND v(dout0_5) AT=195.025n

* CHECK dout0_6 Vdout0_6ck38 = 0 time = 195
.meas tran vdout0_6ck38 FIND v(dout0_6) AT=195.025n

* CHECK dout0_7 Vdout0_7ck38 = 0 time = 195
.meas tran vdout0_7ck38 FIND v(dout0_7) AT=195.025n

* CHECK dout0_0 Vdout0_0ck42 = 1.0 time = 215
.meas tran vdout0_0ck42 FIND v(dout0_0) AT=215.025n

* CHECK dout0_1 Vdout0_1ck42 = 1.0 time = 215
.meas tran vdout0_1ck42 FIND v(dout0_1) AT=215.025n

* CHECK dout0_2 Vdout0_2ck42 = 0 time = 215
.meas tran vdout0_2ck42 FIND v(dout0_2) AT=215.025n

* CHECK dout0_3 Vdout0_3ck42 = 1.0 time = 215
.meas tran vdout0_3ck42 FIND v(dout0_3) AT=215.025n

* CHECK dout0_4 Vdout0_4ck42 = 1.0 time = 215
.meas tran vdout0_4ck42 FIND v(dout0_4) AT=215.025n

* CHECK dout0_5 Vdout0_5ck42 = 1.0 time = 215
.meas tran vdout0_5ck42 FIND v(dout0_5) AT=215.025n

* CHECK dout0_6 Vdout0_6ck42 = 1.0 time = 215
.meas tran vdout0_6ck42 FIND v(dout0_6) AT=215.025n

* CHECK dout0_7 Vdout0_7ck42 = 0 time = 215
.meas tran vdout0_7ck42 FIND v(dout0_7) AT=215.025n

* CHECK dout0_0 Vdout0_0ck43 = 1.0 time = 220
.meas tran vdout0_0ck43 FIND v(dout0_0) AT=220.025n

* CHECK dout0_1 Vdout0_1ck43 = 1.0 time = 220
.meas tran vdout0_1ck43 FIND v(dout0_1) AT=220.025n

* CHECK dout0_2 Vdout0_2ck43 = 0 time = 220
.meas tran vdout0_2ck43 FIND v(dout0_2) AT=220.025n

* CHECK dout0_3 Vdout0_3ck43 = 1.0 time = 220
.meas tran vdout0_3ck43 FIND v(dout0_3) AT=220.025n

* CHECK dout0_4 Vdout0_4ck43 = 0 time = 220
.meas tran vdout0_4ck43 FIND v(dout0_4) AT=220.025n

* CHECK dout0_5 Vdout0_5ck43 = 1.0 time = 220
.meas tran vdout0_5ck43 FIND v(dout0_5) AT=220.025n

* CHECK dout0_6 Vdout0_6ck43 = 0 time = 220
.meas tran vdout0_6ck43 FIND v(dout0_6) AT=220.025n

* CHECK dout0_7 Vdout0_7ck43 = 0 time = 220
.meas tran vdout0_7ck43 FIND v(dout0_7) AT=220.025n

* CHECK dout0_0 Vdout0_0ck44 = 0 time = 225
.meas tran vdout0_0ck44 FIND v(dout0_0) AT=225.025n

* CHECK dout0_1 Vdout0_1ck44 = 0 time = 225
.meas tran vdout0_1ck44 FIND v(dout0_1) AT=225.025n

* CHECK dout0_2 Vdout0_2ck44 = 0 time = 225
.meas tran vdout0_2ck44 FIND v(dout0_2) AT=225.025n

* CHECK dout0_3 Vdout0_3ck44 = 0 time = 225
.meas tran vdout0_3ck44 FIND v(dout0_3) AT=225.025n

* CHECK dout0_4 Vdout0_4ck44 = 0 time = 225
.meas tran vdout0_4ck44 FIND v(dout0_4) AT=225.025n

* CHECK dout0_5 Vdout0_5ck44 = 0 time = 225
.meas tran vdout0_5ck44 FIND v(dout0_5) AT=225.025n

* CHECK dout0_6 Vdout0_6ck44 = 1.0 time = 225
.meas tran vdout0_6ck44 FIND v(dout0_6) AT=225.025n

* CHECK dout0_7 Vdout0_7ck44 = 0 time = 225
.meas tran vdout0_7ck44 FIND v(dout0_7) AT=225.025n

* CHECK dout0_0 Vdout0_0ck46 = 0 time = 235
.meas tran vdout0_0ck46 FIND v(dout0_0) AT=235.025n

* CHECK dout0_1 Vdout0_1ck46 = 1.0 time = 235
.meas tran vdout0_1ck46 FIND v(dout0_1) AT=235.025n

* CHECK dout0_2 Vdout0_2ck46 = 1.0 time = 235
.meas tran vdout0_2ck46 FIND v(dout0_2) AT=235.025n

* CHECK dout0_3 Vdout0_3ck46 = 0 time = 235
.meas tran vdout0_3ck46 FIND v(dout0_3) AT=235.025n

* CHECK dout0_4 Vdout0_4ck46 = 0 time = 235
.meas tran vdout0_4ck46 FIND v(dout0_4) AT=235.025n

* CHECK dout0_5 Vdout0_5ck46 = 0 time = 235
.meas tran vdout0_5ck46 FIND v(dout0_5) AT=235.025n

* CHECK dout0_6 Vdout0_6ck46 = 0 time = 235
.meas tran vdout0_6ck46 FIND v(dout0_6) AT=235.025n

* CHECK dout0_7 Vdout0_7ck46 = 0 time = 235
.meas tran vdout0_7ck46 FIND v(dout0_7) AT=235.025n

* CHECK dout0_0 Vdout0_0ck47 = 0 time = 240
.meas tran vdout0_0ck47 FIND v(dout0_0) AT=240.025n

* CHECK dout0_1 Vdout0_1ck47 = 1.0 time = 240
.meas tran vdout0_1ck47 FIND v(dout0_1) AT=240.025n

* CHECK dout0_2 Vdout0_2ck47 = 1.0 time = 240
.meas tran vdout0_2ck47 FIND v(dout0_2) AT=240.025n

* CHECK dout0_3 Vdout0_3ck47 = 0 time = 240
.meas tran vdout0_3ck47 FIND v(dout0_3) AT=240.025n

* CHECK dout0_4 Vdout0_4ck47 = 0 time = 240
.meas tran vdout0_4ck47 FIND v(dout0_4) AT=240.025n

* CHECK dout0_5 Vdout0_5ck47 = 0 time = 240
.meas tran vdout0_5ck47 FIND v(dout0_5) AT=240.025n

* CHECK dout0_6 Vdout0_6ck47 = 0 time = 240
.meas tran vdout0_6ck47 FIND v(dout0_6) AT=240.025n

* CHECK dout0_7 Vdout0_7ck47 = 0 time = 240
.meas tran vdout0_7ck47 FIND v(dout0_7) AT=240.025n

* CHECK dout0_0 Vdout0_0ck48 = 1.0 time = 245
.meas tran vdout0_0ck48 FIND v(dout0_0) AT=245.025n

* CHECK dout0_1 Vdout0_1ck48 = 1.0 time = 245
.meas tran vdout0_1ck48 FIND v(dout0_1) AT=245.025n

* CHECK dout0_2 Vdout0_2ck48 = 0 time = 245
.meas tran vdout0_2ck48 FIND v(dout0_2) AT=245.025n

* CHECK dout0_3 Vdout0_3ck48 = 1.0 time = 245
.meas tran vdout0_3ck48 FIND v(dout0_3) AT=245.025n

* CHECK dout0_4 Vdout0_4ck48 = 0 time = 245
.meas tran vdout0_4ck48 FIND v(dout0_4) AT=245.025n

* CHECK dout0_5 Vdout0_5ck48 = 1.0 time = 245
.meas tran vdout0_5ck48 FIND v(dout0_5) AT=245.025n

* CHECK dout0_6 Vdout0_6ck48 = 0 time = 245
.meas tran vdout0_6ck48 FIND v(dout0_6) AT=245.025n

* CHECK dout0_7 Vdout0_7ck48 = 1.0 time = 245
.meas tran vdout0_7ck48 FIND v(dout0_7) AT=245.025n

* CHECK dout0_0 Vdout0_0ck49 = 1.0 time = 250
.meas tran vdout0_0ck49 FIND v(dout0_0) AT=250.025n

* CHECK dout0_1 Vdout0_1ck49 = 0 time = 250
.meas tran vdout0_1ck49 FIND v(dout0_1) AT=250.025n

* CHECK dout0_2 Vdout0_2ck49 = 0 time = 250
.meas tran vdout0_2ck49 FIND v(dout0_2) AT=250.025n

* CHECK dout0_3 Vdout0_3ck49 = 1.0 time = 250
.meas tran vdout0_3ck49 FIND v(dout0_3) AT=250.025n

* CHECK dout0_4 Vdout0_4ck49 = 1.0 time = 250
.meas tran vdout0_4ck49 FIND v(dout0_4) AT=250.025n

* CHECK dout0_5 Vdout0_5ck49 = 0 time = 250
.meas tran vdout0_5ck49 FIND v(dout0_5) AT=250.025n

* CHECK dout0_6 Vdout0_6ck49 = 1.0 time = 250
.meas tran vdout0_6ck49 FIND v(dout0_6) AT=250.025n

* CHECK dout0_7 Vdout0_7ck49 = 1.0 time = 250
.meas tran vdout0_7ck49 FIND v(dout0_7) AT=250.025n

* CHECK dout0_0 Vdout0_0ck54 = 1.0 time = 275
.meas tran vdout0_0ck54 FIND v(dout0_0) AT=275.025n

* CHECK dout0_1 Vdout0_1ck54 = 0 time = 275
.meas tran vdout0_1ck54 FIND v(dout0_1) AT=275.025n

* CHECK dout0_2 Vdout0_2ck54 = 0 time = 275
.meas tran vdout0_2ck54 FIND v(dout0_2) AT=275.025n

* CHECK dout0_3 Vdout0_3ck54 = 0 time = 275
.meas tran vdout0_3ck54 FIND v(dout0_3) AT=275.025n

* CHECK dout0_4 Vdout0_4ck54 = 0 time = 275
.meas tran vdout0_4ck54 FIND v(dout0_4) AT=275.025n

* CHECK dout0_5 Vdout0_5ck54 = 1.0 time = 275
.meas tran vdout0_5ck54 FIND v(dout0_5) AT=275.025n

* CHECK dout0_6 Vdout0_6ck54 = 0 time = 275
.meas tran vdout0_6ck54 FIND v(dout0_6) AT=275.025n

* CHECK dout0_7 Vdout0_7ck54 = 0 time = 275
.meas tran vdout0_7ck54 FIND v(dout0_7) AT=275.025n

* CHECK dout0_0 Vdout0_0ck56 = 1.0 time = 285
.meas tran vdout0_0ck56 FIND v(dout0_0) AT=285.025n

* CHECK dout0_1 Vdout0_1ck56 = 1.0 time = 285
.meas tran vdout0_1ck56 FIND v(dout0_1) AT=285.025n

* CHECK dout0_2 Vdout0_2ck56 = 0 time = 285
.meas tran vdout0_2ck56 FIND v(dout0_2) AT=285.025n

* CHECK dout0_3 Vdout0_3ck56 = 1.0 time = 285
.meas tran vdout0_3ck56 FIND v(dout0_3) AT=285.025n

* CHECK dout0_4 Vdout0_4ck56 = 0 time = 285
.meas tran vdout0_4ck56 FIND v(dout0_4) AT=285.025n

* CHECK dout0_5 Vdout0_5ck56 = 1.0 time = 285
.meas tran vdout0_5ck56 FIND v(dout0_5) AT=285.025n

* CHECK dout0_6 Vdout0_6ck56 = 0 time = 285
.meas tran vdout0_6ck56 FIND v(dout0_6) AT=285.025n

* CHECK dout0_7 Vdout0_7ck56 = 0 time = 285
.meas tran vdout0_7ck56 FIND v(dout0_7) AT=285.025n

* CHECK dout0_0 Vdout0_0ck59 = 0 time = 300
.meas tran vdout0_0ck59 FIND v(dout0_0) AT=300.025n

* CHECK dout0_1 Vdout0_1ck59 = 0 time = 300
.meas tran vdout0_1ck59 FIND v(dout0_1) AT=300.025n

* CHECK dout0_2 Vdout0_2ck59 = 0 time = 300
.meas tran vdout0_2ck59 FIND v(dout0_2) AT=300.025n

* CHECK dout0_3 Vdout0_3ck59 = 0 time = 300
.meas tran vdout0_3ck59 FIND v(dout0_3) AT=300.025n

* CHECK dout0_4 Vdout0_4ck59 = 0 time = 300
.meas tran vdout0_4ck59 FIND v(dout0_4) AT=300.025n

* CHECK dout0_5 Vdout0_5ck59 = 0 time = 300
.meas tran vdout0_5ck59 FIND v(dout0_5) AT=300.025n

* CHECK dout0_6 Vdout0_6ck59 = 1.0 time = 300
.meas tran vdout0_6ck59 FIND v(dout0_6) AT=300.025n

* CHECK dout0_7 Vdout0_7ck59 = 0 time = 300
.meas tran vdout0_7ck59 FIND v(dout0_7) AT=300.025n

* CHECK dout0_0 Vdout0_0ck60 = 1.0 time = 305
.meas tran vdout0_0ck60 FIND v(dout0_0) AT=305.025n

* CHECK dout0_1 Vdout0_1ck60 = 1.0 time = 305
.meas tran vdout0_1ck60 FIND v(dout0_1) AT=305.025n

* CHECK dout0_2 Vdout0_2ck60 = 0 time = 305
.meas tran vdout0_2ck60 FIND v(dout0_2) AT=305.025n

* CHECK dout0_3 Vdout0_3ck60 = 1.0 time = 305
.meas tran vdout0_3ck60 FIND v(dout0_3) AT=305.025n

* CHECK dout0_4 Vdout0_4ck60 = 0 time = 305
.meas tran vdout0_4ck60 FIND v(dout0_4) AT=305.025n

* CHECK dout0_5 Vdout0_5ck60 = 1.0 time = 305
.meas tran vdout0_5ck60 FIND v(dout0_5) AT=305.025n

* CHECK dout0_6 Vdout0_6ck60 = 0 time = 305
.meas tran vdout0_6ck60 FIND v(dout0_6) AT=305.025n

* CHECK dout0_7 Vdout0_7ck60 = 1.0 time = 305
.meas tran vdout0_7ck60 FIND v(dout0_7) AT=305.025n

* CHECK dout0_0 Vdout0_0ck61 = 1.0 time = 310
.meas tran vdout0_0ck61 FIND v(dout0_0) AT=310.025n

* CHECK dout0_1 Vdout0_1ck61 = 0 time = 310
.meas tran vdout0_1ck61 FIND v(dout0_1) AT=310.025n

* CHECK dout0_2 Vdout0_2ck61 = 1.0 time = 310
.meas tran vdout0_2ck61 FIND v(dout0_2) AT=310.025n

* CHECK dout0_3 Vdout0_3ck61 = 1.0 time = 310
.meas tran vdout0_3ck61 FIND v(dout0_3) AT=310.025n

* CHECK dout0_4 Vdout0_4ck61 = 1.0 time = 310
.meas tran vdout0_4ck61 FIND v(dout0_4) AT=310.025n

* CHECK dout0_5 Vdout0_5ck61 = 1.0 time = 310
.meas tran vdout0_5ck61 FIND v(dout0_5) AT=310.025n

* CHECK dout0_6 Vdout0_6ck61 = 1.0 time = 310
.meas tran vdout0_6ck61 FIND v(dout0_6) AT=310.025n

* CHECK dout0_7 Vdout0_7ck61 = 0 time = 310
.meas tran vdout0_7ck61 FIND v(dout0_7) AT=310.025n

* CHECK dout0_0 Vdout0_0ck62 = 1.0 time = 315
.meas tran vdout0_0ck62 FIND v(dout0_0) AT=315.025n

* CHECK dout0_1 Vdout0_1ck62 = 0 time = 315
.meas tran vdout0_1ck62 FIND v(dout0_1) AT=315.025n

* CHECK dout0_2 Vdout0_2ck62 = 0 time = 315
.meas tran vdout0_2ck62 FIND v(dout0_2) AT=315.025n

* CHECK dout0_3 Vdout0_3ck62 = 0 time = 315
.meas tran vdout0_3ck62 FIND v(dout0_3) AT=315.025n

* CHECK dout0_4 Vdout0_4ck62 = 0 time = 315
.meas tran vdout0_4ck62 FIND v(dout0_4) AT=315.025n

* CHECK dout0_5 Vdout0_5ck62 = 1.0 time = 315
.meas tran vdout0_5ck62 FIND v(dout0_5) AT=315.025n

* CHECK dout0_6 Vdout0_6ck62 = 0 time = 315
.meas tran vdout0_6ck62 FIND v(dout0_6) AT=315.025n

* CHECK dout0_7 Vdout0_7ck62 = 0 time = 315
.meas tran vdout0_7ck62 FIND v(dout0_7) AT=315.025n

* CHECK dout0_0 Vdout0_0ck63 = 1.0 time = 320
.meas tran vdout0_0ck63 FIND v(dout0_0) AT=320.025n

* CHECK dout0_1 Vdout0_1ck63 = 1.0 time = 320
.meas tran vdout0_1ck63 FIND v(dout0_1) AT=320.025n

* CHECK dout0_2 Vdout0_2ck63 = 1.0 time = 320
.meas tran vdout0_2ck63 FIND v(dout0_2) AT=320.025n

* CHECK dout0_3 Vdout0_3ck63 = 0 time = 320
.meas tran vdout0_3ck63 FIND v(dout0_3) AT=320.025n

* CHECK dout0_4 Vdout0_4ck63 = 0 time = 320
.meas tran vdout0_4ck63 FIND v(dout0_4) AT=320.025n

* CHECK dout0_5 Vdout0_5ck63 = 0 time = 320
.meas tran vdout0_5ck63 FIND v(dout0_5) AT=320.025n

* CHECK dout0_6 Vdout0_6ck63 = 0 time = 320
.meas tran vdout0_6ck63 FIND v(dout0_6) AT=320.025n

* CHECK dout0_7 Vdout0_7ck63 = 0 time = 320
.meas tran vdout0_7ck63 FIND v(dout0_7) AT=320.025n

* CHECK dout0_0 Vdout0_0ck65 = 0 time = 330
.meas tran vdout0_0ck65 FIND v(dout0_0) AT=330.025n

* CHECK dout0_1 Vdout0_1ck65 = 1.0 time = 330
.meas tran vdout0_1ck65 FIND v(dout0_1) AT=330.025n

* CHECK dout0_2 Vdout0_2ck65 = 0 time = 330
.meas tran vdout0_2ck65 FIND v(dout0_2) AT=330.025n

* CHECK dout0_3 Vdout0_3ck65 = 1.0 time = 330
.meas tran vdout0_3ck65 FIND v(dout0_3) AT=330.025n

* CHECK dout0_4 Vdout0_4ck65 = 1.0 time = 330
.meas tran vdout0_4ck65 FIND v(dout0_4) AT=330.025n

* CHECK dout0_5 Vdout0_5ck65 = 1.0 time = 330
.meas tran vdout0_5ck65 FIND v(dout0_5) AT=330.025n

* CHECK dout0_6 Vdout0_6ck65 = 0 time = 330
.meas tran vdout0_6ck65 FIND v(dout0_6) AT=330.025n

* CHECK dout0_7 Vdout0_7ck65 = 1.0 time = 330
.meas tran vdout0_7ck65 FIND v(dout0_7) AT=330.025n

* CHECK dout0_0 Vdout0_0ck67 = 0 time = 340
.meas tran vdout0_0ck67 FIND v(dout0_0) AT=340.025n

* CHECK dout0_1 Vdout0_1ck67 = 1.0 time = 340
.meas tran vdout0_1ck67 FIND v(dout0_1) AT=340.025n

* CHECK dout0_2 Vdout0_2ck67 = 0 time = 340
.meas tran vdout0_2ck67 FIND v(dout0_2) AT=340.025n

* CHECK dout0_3 Vdout0_3ck67 = 1.0 time = 340
.meas tran vdout0_3ck67 FIND v(dout0_3) AT=340.025n

* CHECK dout0_4 Vdout0_4ck67 = 1.0 time = 340
.meas tran vdout0_4ck67 FIND v(dout0_4) AT=340.025n

* CHECK dout0_5 Vdout0_5ck67 = 1.0 time = 340
.meas tran vdout0_5ck67 FIND v(dout0_5) AT=340.025n

* CHECK dout0_6 Vdout0_6ck67 = 0 time = 340
.meas tran vdout0_6ck67 FIND v(dout0_6) AT=340.025n

* CHECK dout0_7 Vdout0_7ck67 = 1.0 time = 340
.meas tran vdout0_7ck67 FIND v(dout0_7) AT=340.025n

* CHECK dout0_0 Vdout0_0ck68 = 1.0 time = 345
.meas tran vdout0_0ck68 FIND v(dout0_0) AT=345.025n

* CHECK dout0_1 Vdout0_1ck68 = 0 time = 345
.meas tran vdout0_1ck68 FIND v(dout0_1) AT=345.025n

* CHECK dout0_2 Vdout0_2ck68 = 0 time = 345
.meas tran vdout0_2ck68 FIND v(dout0_2) AT=345.025n

* CHECK dout0_3 Vdout0_3ck68 = 0 time = 345
.meas tran vdout0_3ck68 FIND v(dout0_3) AT=345.025n

* CHECK dout0_4 Vdout0_4ck68 = 0 time = 345
.meas tran vdout0_4ck68 FIND v(dout0_4) AT=345.025n

* CHECK dout0_5 Vdout0_5ck68 = 1.0 time = 345
.meas tran vdout0_5ck68 FIND v(dout0_5) AT=345.025n

* CHECK dout0_6 Vdout0_6ck68 = 0 time = 345
.meas tran vdout0_6ck68 FIND v(dout0_6) AT=345.025n

* CHECK dout0_7 Vdout0_7ck68 = 0 time = 345
.meas tran vdout0_7ck68 FIND v(dout0_7) AT=345.025n

* CHECK dout0_0 Vdout0_0ck73 = 0 time = 370
.meas tran vdout0_0ck73 FIND v(dout0_0) AT=370.025n

* CHECK dout0_1 Vdout0_1ck73 = 0 time = 370
.meas tran vdout0_1ck73 FIND v(dout0_1) AT=370.025n

* CHECK dout0_2 Vdout0_2ck73 = 0 time = 370
.meas tran vdout0_2ck73 FIND v(dout0_2) AT=370.025n

* CHECK dout0_3 Vdout0_3ck73 = 1.0 time = 370
.meas tran vdout0_3ck73 FIND v(dout0_3) AT=370.025n

* CHECK dout0_4 Vdout0_4ck73 = 0 time = 370
.meas tran vdout0_4ck73 FIND v(dout0_4) AT=370.025n

* CHECK dout0_5 Vdout0_5ck73 = 0 time = 370
.meas tran vdout0_5ck73 FIND v(dout0_5) AT=370.025n

* CHECK dout0_6 Vdout0_6ck73 = 0 time = 370
.meas tran vdout0_6ck73 FIND v(dout0_6) AT=370.025n

* CHECK dout0_7 Vdout0_7ck73 = 1.0 time = 370
.meas tran vdout0_7ck73 FIND v(dout0_7) AT=370.025n

* CHECK dout0_0 Vdout0_0ck74 = 0 time = 375
.meas tran vdout0_0ck74 FIND v(dout0_0) AT=375.025n

* CHECK dout0_1 Vdout0_1ck74 = 1.0 time = 375
.meas tran vdout0_1ck74 FIND v(dout0_1) AT=375.025n

* CHECK dout0_2 Vdout0_2ck74 = 1.0 time = 375
.meas tran vdout0_2ck74 FIND v(dout0_2) AT=375.025n

* CHECK dout0_3 Vdout0_3ck74 = 0 time = 375
.meas tran vdout0_3ck74 FIND v(dout0_3) AT=375.025n

* CHECK dout0_4 Vdout0_4ck74 = 0 time = 375
.meas tran vdout0_4ck74 FIND v(dout0_4) AT=375.025n

* CHECK dout0_5 Vdout0_5ck74 = 0 time = 375
.meas tran vdout0_5ck74 FIND v(dout0_5) AT=375.025n

* CHECK dout0_6 Vdout0_6ck74 = 0 time = 375
.meas tran vdout0_6ck74 FIND v(dout0_6) AT=375.025n

* CHECK dout0_7 Vdout0_7ck74 = 0 time = 375
.meas tran vdout0_7ck74 FIND v(dout0_7) AT=375.025n

* CHECK dout0_0 Vdout0_0ck76 = 0 time = 385
.meas tran vdout0_0ck76 FIND v(dout0_0) AT=385.025n

* CHECK dout0_1 Vdout0_1ck76 = 0 time = 385
.meas tran vdout0_1ck76 FIND v(dout0_1) AT=385.025n

* CHECK dout0_2 Vdout0_2ck76 = 0 time = 385
.meas tran vdout0_2ck76 FIND v(dout0_2) AT=385.025n

* CHECK dout0_3 Vdout0_3ck76 = 0 time = 385
.meas tran vdout0_3ck76 FIND v(dout0_3) AT=385.025n

* CHECK dout0_4 Vdout0_4ck76 = 0 time = 385
.meas tran vdout0_4ck76 FIND v(dout0_4) AT=385.025n

* CHECK dout0_5 Vdout0_5ck76 = 0 time = 385
.meas tran vdout0_5ck76 FIND v(dout0_5) AT=385.025n

* CHECK dout0_6 Vdout0_6ck76 = 1.0 time = 385
.meas tran vdout0_6ck76 FIND v(dout0_6) AT=385.025n

* CHECK dout0_7 Vdout0_7ck76 = 0 time = 385
.meas tran vdout0_7ck76 FIND v(dout0_7) AT=385.025n

* CHECK dout0_0 Vdout0_0ck77 = 0 time = 390
.meas tran vdout0_0ck77 FIND v(dout0_0) AT=390.025n

* CHECK dout0_1 Vdout0_1ck77 = 0 time = 390
.meas tran vdout0_1ck77 FIND v(dout0_1) AT=390.025n

* CHECK dout0_2 Vdout0_2ck77 = 0 time = 390
.meas tran vdout0_2ck77 FIND v(dout0_2) AT=390.025n

* CHECK dout0_3 Vdout0_3ck77 = 1.0 time = 390
.meas tran vdout0_3ck77 FIND v(dout0_3) AT=390.025n

* CHECK dout0_4 Vdout0_4ck77 = 0 time = 390
.meas tran vdout0_4ck77 FIND v(dout0_4) AT=390.025n

* CHECK dout0_5 Vdout0_5ck77 = 0 time = 390
.meas tran vdout0_5ck77 FIND v(dout0_5) AT=390.025n

* CHECK dout0_6 Vdout0_6ck77 = 0 time = 390
.meas tran vdout0_6ck77 FIND v(dout0_6) AT=390.025n

* CHECK dout0_7 Vdout0_7ck77 = 1.0 time = 390
.meas tran vdout0_7ck77 FIND v(dout0_7) AT=390.025n

* CHECK dout0_0 Vdout0_0ck78 = 1.0 time = 395
.meas tran vdout0_0ck78 FIND v(dout0_0) AT=395.025n

* CHECK dout0_1 Vdout0_1ck78 = 1.0 time = 395
.meas tran vdout0_1ck78 FIND v(dout0_1) AT=395.025n

* CHECK dout0_2 Vdout0_2ck78 = 0 time = 395
.meas tran vdout0_2ck78 FIND v(dout0_2) AT=395.025n

* CHECK dout0_3 Vdout0_3ck78 = 1.0 time = 395
.meas tran vdout0_3ck78 FIND v(dout0_3) AT=395.025n

* CHECK dout0_4 Vdout0_4ck78 = 0 time = 395
.meas tran vdout0_4ck78 FIND v(dout0_4) AT=395.025n

* CHECK dout0_5 Vdout0_5ck78 = 1.0 time = 395
.meas tran vdout0_5ck78 FIND v(dout0_5) AT=395.025n

* CHECK dout0_6 Vdout0_6ck78 = 0 time = 395
.meas tran vdout0_6ck78 FIND v(dout0_6) AT=395.025n

* CHECK dout0_7 Vdout0_7ck78 = 0 time = 395
.meas tran vdout0_7ck78 FIND v(dout0_7) AT=395.025n

* CHECK dout0_0 Vdout0_0ck81 = 1.0 time = 410
.meas tran vdout0_0ck81 FIND v(dout0_0) AT=410.025n

* CHECK dout0_1 Vdout0_1ck81 = 1.0 time = 410
.meas tran vdout0_1ck81 FIND v(dout0_1) AT=410.025n

* CHECK dout0_2 Vdout0_2ck81 = 0 time = 410
.meas tran vdout0_2ck81 FIND v(dout0_2) AT=410.025n

* CHECK dout0_3 Vdout0_3ck81 = 1.0 time = 410
.meas tran vdout0_3ck81 FIND v(dout0_3) AT=410.025n

* CHECK dout0_4 Vdout0_4ck81 = 0 time = 410
.meas tran vdout0_4ck81 FIND v(dout0_4) AT=410.025n

* CHECK dout0_5 Vdout0_5ck81 = 1.0 time = 410
.meas tran vdout0_5ck81 FIND v(dout0_5) AT=410.025n

* CHECK dout0_6 Vdout0_6ck81 = 0 time = 410
.meas tran vdout0_6ck81 FIND v(dout0_6) AT=410.025n

* CHECK dout0_7 Vdout0_7ck81 = 0 time = 410
.meas tran vdout0_7ck81 FIND v(dout0_7) AT=410.025n

* CHECK dout0_0 Vdout0_0ck84 = 1.0 time = 425
.meas tran vdout0_0ck84 FIND v(dout0_0) AT=425.025n

* CHECK dout0_1 Vdout0_1ck84 = 0 time = 425
.meas tran vdout0_1ck84 FIND v(dout0_1) AT=425.025n

* CHECK dout0_2 Vdout0_2ck84 = 0 time = 425
.meas tran vdout0_2ck84 FIND v(dout0_2) AT=425.025n

* CHECK dout0_3 Vdout0_3ck84 = 1.0 time = 425
.meas tran vdout0_3ck84 FIND v(dout0_3) AT=425.025n

* CHECK dout0_4 Vdout0_4ck84 = 1.0 time = 425
.meas tran vdout0_4ck84 FIND v(dout0_4) AT=425.025n

* CHECK dout0_5 Vdout0_5ck84 = 0 time = 425
.meas tran vdout0_5ck84 FIND v(dout0_5) AT=425.025n

* CHECK dout0_6 Vdout0_6ck84 = 1.0 time = 425
.meas tran vdout0_6ck84 FIND v(dout0_6) AT=425.025n

* CHECK dout0_7 Vdout0_7ck84 = 1.0 time = 425
.meas tran vdout0_7ck84 FIND v(dout0_7) AT=425.025n

* CHECK dout0_0 Vdout0_0ck85 = 1.0 time = 430
.meas tran vdout0_0ck85 FIND v(dout0_0) AT=430.025n

* CHECK dout0_1 Vdout0_1ck85 = 1.0 time = 430
.meas tran vdout0_1ck85 FIND v(dout0_1) AT=430.025n

* CHECK dout0_2 Vdout0_2ck85 = 0 time = 430
.meas tran vdout0_2ck85 FIND v(dout0_2) AT=430.025n

* CHECK dout0_3 Vdout0_3ck85 = 1.0 time = 430
.meas tran vdout0_3ck85 FIND v(dout0_3) AT=430.025n

* CHECK dout0_4 Vdout0_4ck85 = 0 time = 430
.meas tran vdout0_4ck85 FIND v(dout0_4) AT=430.025n

* CHECK dout0_5 Vdout0_5ck85 = 1.0 time = 430
.meas tran vdout0_5ck85 FIND v(dout0_5) AT=430.025n

* CHECK dout0_6 Vdout0_6ck85 = 0 time = 430
.meas tran vdout0_6ck85 FIND v(dout0_6) AT=430.025n

* CHECK dout0_7 Vdout0_7ck85 = 0 time = 430
.meas tran vdout0_7ck85 FIND v(dout0_7) AT=430.025n

* CHECK dout0_0 Vdout0_0ck86 = 0 time = 435
.meas tran vdout0_0ck86 FIND v(dout0_0) AT=435.025n

* CHECK dout0_1 Vdout0_1ck86 = 0 time = 435
.meas tran vdout0_1ck86 FIND v(dout0_1) AT=435.025n

* CHECK dout0_2 Vdout0_2ck86 = 0 time = 435
.meas tran vdout0_2ck86 FIND v(dout0_2) AT=435.025n

* CHECK dout0_3 Vdout0_3ck86 = 1.0 time = 435
.meas tran vdout0_3ck86 FIND v(dout0_3) AT=435.025n

* CHECK dout0_4 Vdout0_4ck86 = 0 time = 435
.meas tran vdout0_4ck86 FIND v(dout0_4) AT=435.025n

* CHECK dout0_5 Vdout0_5ck86 = 0 time = 435
.meas tran vdout0_5ck86 FIND v(dout0_5) AT=435.025n

* CHECK dout0_6 Vdout0_6ck86 = 0 time = 435
.meas tran vdout0_6ck86 FIND v(dout0_6) AT=435.025n

* CHECK dout0_7 Vdout0_7ck86 = 1.0 time = 435
.meas tran vdout0_7ck86 FIND v(dout0_7) AT=435.025n

* CHECK dout0_0 Vdout0_0ck87 = 0 time = 440
.meas tran vdout0_0ck87 FIND v(dout0_0) AT=440.025n

* CHECK dout0_1 Vdout0_1ck87 = 1.0 time = 440
.meas tran vdout0_1ck87 FIND v(dout0_1) AT=440.025n

* CHECK dout0_2 Vdout0_2ck87 = 1.0 time = 440
.meas tran vdout0_2ck87 FIND v(dout0_2) AT=440.025n

* CHECK dout0_3 Vdout0_3ck87 = 1.0 time = 440
.meas tran vdout0_3ck87 FIND v(dout0_3) AT=440.025n

* CHECK dout0_4 Vdout0_4ck87 = 1.0 time = 440
.meas tran vdout0_4ck87 FIND v(dout0_4) AT=440.025n

* CHECK dout0_5 Vdout0_5ck87 = 1.0 time = 440
.meas tran vdout0_5ck87 FIND v(dout0_5) AT=440.025n

* CHECK dout0_6 Vdout0_6ck87 = 0 time = 440
.meas tran vdout0_6ck87 FIND v(dout0_6) AT=440.025n

* CHECK dout0_7 Vdout0_7ck87 = 0 time = 440
.meas tran vdout0_7ck87 FIND v(dout0_7) AT=440.025n

* CHECK dout0_0 Vdout0_0ck88 = 1.0 time = 445
.meas tran vdout0_0ck88 FIND v(dout0_0) AT=445.025n

* CHECK dout0_1 Vdout0_1ck88 = 1.0 time = 445
.meas tran vdout0_1ck88 FIND v(dout0_1) AT=445.025n

* CHECK dout0_2 Vdout0_2ck88 = 0 time = 445
.meas tran vdout0_2ck88 FIND v(dout0_2) AT=445.025n

* CHECK dout0_3 Vdout0_3ck88 = 1.0 time = 445
.meas tran vdout0_3ck88 FIND v(dout0_3) AT=445.025n

* CHECK dout0_4 Vdout0_4ck88 = 0 time = 445
.meas tran vdout0_4ck88 FIND v(dout0_4) AT=445.025n

* CHECK dout0_5 Vdout0_5ck88 = 1.0 time = 445
.meas tran vdout0_5ck88 FIND v(dout0_5) AT=445.025n

* CHECK dout0_6 Vdout0_6ck88 = 0 time = 445
.meas tran vdout0_6ck88 FIND v(dout0_6) AT=445.025n

* CHECK dout0_7 Vdout0_7ck88 = 1.0 time = 445
.meas tran vdout0_7ck88 FIND v(dout0_7) AT=445.025n

* CHECK dout0_0 Vdout0_0ck92 = 1.0 time = 465
.meas tran vdout0_0ck92 FIND v(dout0_0) AT=465.025n

* CHECK dout0_1 Vdout0_1ck92 = 1.0 time = 465
.meas tran vdout0_1ck92 FIND v(dout0_1) AT=465.025n

* CHECK dout0_2 Vdout0_2ck92 = 1.0 time = 465
.meas tran vdout0_2ck92 FIND v(dout0_2) AT=465.025n

* CHECK dout0_3 Vdout0_3ck92 = 0 time = 465
.meas tran vdout0_3ck92 FIND v(dout0_3) AT=465.025n

* CHECK dout0_4 Vdout0_4ck92 = 0 time = 465
.meas tran vdout0_4ck92 FIND v(dout0_4) AT=465.025n

* CHECK dout0_5 Vdout0_5ck92 = 0 time = 465
.meas tran vdout0_5ck92 FIND v(dout0_5) AT=465.025n

* CHECK dout0_6 Vdout0_6ck92 = 0 time = 465
.meas tran vdout0_6ck92 FIND v(dout0_6) AT=465.025n

* CHECK dout0_7 Vdout0_7ck92 = 0 time = 465
.meas tran vdout0_7ck92 FIND v(dout0_7) AT=465.025n

* CHECK dout0_0 Vdout0_0ck96 = 1.0 time = 485
.meas tran vdout0_0ck96 FIND v(dout0_0) AT=485.025n

* CHECK dout0_1 Vdout0_1ck96 = 1.0 time = 485
.meas tran vdout0_1ck96 FIND v(dout0_1) AT=485.025n

* CHECK dout0_2 Vdout0_2ck96 = 0 time = 485
.meas tran vdout0_2ck96 FIND v(dout0_2) AT=485.025n

* CHECK dout0_3 Vdout0_3ck96 = 1.0 time = 485
.meas tran vdout0_3ck96 FIND v(dout0_3) AT=485.025n

* CHECK dout0_4 Vdout0_4ck96 = 1.0 time = 485
.meas tran vdout0_4ck96 FIND v(dout0_4) AT=485.025n

* CHECK dout0_5 Vdout0_5ck96 = 1.0 time = 485
.meas tran vdout0_5ck96 FIND v(dout0_5) AT=485.025n

* CHECK dout0_6 Vdout0_6ck96 = 1.0 time = 485
.meas tran vdout0_6ck96 FIND v(dout0_6) AT=485.025n

* CHECK dout0_7 Vdout0_7ck96 = 0 time = 485
.meas tran vdout0_7ck96 FIND v(dout0_7) AT=485.025n

* CHECK dout0_0 Vdout0_0ck97 = 1.0 time = 490
.meas tran vdout0_0ck97 FIND v(dout0_0) AT=490.025n

* CHECK dout0_1 Vdout0_1ck97 = 1.0 time = 490
.meas tran vdout0_1ck97 FIND v(dout0_1) AT=490.025n

* CHECK dout0_2 Vdout0_2ck97 = 1.0 time = 490
.meas tran vdout0_2ck97 FIND v(dout0_2) AT=490.025n

* CHECK dout0_3 Vdout0_3ck97 = 0 time = 490
.meas tran vdout0_3ck97 FIND v(dout0_3) AT=490.025n

* CHECK dout0_4 Vdout0_4ck97 = 0 time = 490
.meas tran vdout0_4ck97 FIND v(dout0_4) AT=490.025n

* CHECK dout0_5 Vdout0_5ck97 = 0 time = 490
.meas tran vdout0_5ck97 FIND v(dout0_5) AT=490.025n

* CHECK dout0_6 Vdout0_6ck97 = 0 time = 490
.meas tran vdout0_6ck97 FIND v(dout0_6) AT=490.025n

* CHECK dout0_7 Vdout0_7ck97 = 0 time = 490
.meas tran vdout0_7ck97 FIND v(dout0_7) AT=490.025n

* CHECK dout0_0 Vdout0_0ck99 = 0 time = 500
.meas tran vdout0_0ck99 FIND v(dout0_0) AT=500.025n

* CHECK dout0_1 Vdout0_1ck99 = 1.0 time = 500
.meas tran vdout0_1ck99 FIND v(dout0_1) AT=500.025n

* CHECK dout0_2 Vdout0_2ck99 = 1.0 time = 500
.meas tran vdout0_2ck99 FIND v(dout0_2) AT=500.025n

* CHECK dout0_3 Vdout0_3ck99 = 0 time = 500
.meas tran vdout0_3ck99 FIND v(dout0_3) AT=500.025n

* CHECK dout0_4 Vdout0_4ck99 = 0 time = 500
.meas tran vdout0_4ck99 FIND v(dout0_4) AT=500.025n

* CHECK dout0_5 Vdout0_5ck99 = 0 time = 500
.meas tran vdout0_5ck99 FIND v(dout0_5) AT=500.025n

* CHECK dout0_6 Vdout0_6ck99 = 0 time = 500
.meas tran vdout0_6ck99 FIND v(dout0_6) AT=500.025n

* CHECK dout0_7 Vdout0_7ck99 = 0 time = 500
.meas tran vdout0_7ck99 FIND v(dout0_7) AT=500.025n

* CHECK dout0_0 Vdout0_0ck100 = 0 time = 505
.meas tran vdout0_0ck100 FIND v(dout0_0) AT=505.025n

* CHECK dout0_1 Vdout0_1ck100 = 1.0 time = 505
.meas tran vdout0_1ck100 FIND v(dout0_1) AT=505.025n

* CHECK dout0_2 Vdout0_2ck100 = 1.0 time = 505
.meas tran vdout0_2ck100 FIND v(dout0_2) AT=505.025n

* CHECK dout0_3 Vdout0_3ck100 = 1.0 time = 505
.meas tran vdout0_3ck100 FIND v(dout0_3) AT=505.025n

* CHECK dout0_4 Vdout0_4ck100 = 1.0 time = 505
.meas tran vdout0_4ck100 FIND v(dout0_4) AT=505.025n

* CHECK dout0_5 Vdout0_5ck100 = 1.0 time = 505
.meas tran vdout0_5ck100 FIND v(dout0_5) AT=505.025n

* CHECK dout0_6 Vdout0_6ck100 = 0 time = 505
.meas tran vdout0_6ck100 FIND v(dout0_6) AT=505.025n

* CHECK dout0_7 Vdout0_7ck100 = 0 time = 505
.meas tran vdout0_7ck100 FIND v(dout0_7) AT=505.025n

* CHECK dout0_0 Vdout0_0ck101 = 1.0 time = 510
.meas tran vdout0_0ck101 FIND v(dout0_0) AT=510.025n

* CHECK dout0_1 Vdout0_1ck101 = 0 time = 510
.meas tran vdout0_1ck101 FIND v(dout0_1) AT=510.025n

* CHECK dout0_2 Vdout0_2ck101 = 0 time = 510
.meas tran vdout0_2ck101 FIND v(dout0_2) AT=510.025n

* CHECK dout0_3 Vdout0_3ck101 = 0 time = 510
.meas tran vdout0_3ck101 FIND v(dout0_3) AT=510.025n

* CHECK dout0_4 Vdout0_4ck101 = 0 time = 510
.meas tran vdout0_4ck101 FIND v(dout0_4) AT=510.025n

* CHECK dout0_5 Vdout0_5ck101 = 1.0 time = 510
.meas tran vdout0_5ck101 FIND v(dout0_5) AT=510.025n

* CHECK dout0_6 Vdout0_6ck101 = 0 time = 510
.meas tran vdout0_6ck101 FIND v(dout0_6) AT=510.025n

* CHECK dout0_7 Vdout0_7ck101 = 0 time = 510
.meas tran vdout0_7ck101 FIND v(dout0_7) AT=510.025n

* CHECK dout0_0 Vdout0_0ck103 = 0 time = 520
.meas tran vdout0_0ck103 FIND v(dout0_0) AT=520.025n

* CHECK dout0_1 Vdout0_1ck103 = 0 time = 520
.meas tran vdout0_1ck103 FIND v(dout0_1) AT=520.025n

* CHECK dout0_2 Vdout0_2ck103 = 0 time = 520
.meas tran vdout0_2ck103 FIND v(dout0_2) AT=520.025n

* CHECK dout0_3 Vdout0_3ck103 = 1.0 time = 520
.meas tran vdout0_3ck103 FIND v(dout0_3) AT=520.025n

* CHECK dout0_4 Vdout0_4ck103 = 0 time = 520
.meas tran vdout0_4ck103 FIND v(dout0_4) AT=520.025n

* CHECK dout0_5 Vdout0_5ck103 = 0 time = 520
.meas tran vdout0_5ck103 FIND v(dout0_5) AT=520.025n

* CHECK dout0_6 Vdout0_6ck103 = 0 time = 520
.meas tran vdout0_6ck103 FIND v(dout0_6) AT=520.025n

* CHECK dout0_7 Vdout0_7ck103 = 1.0 time = 520
.meas tran vdout0_7ck103 FIND v(dout0_7) AT=520.025n

* CHECK dout0_0 Vdout0_0ck105 = 1.0 time = 530
.meas tran vdout0_0ck105 FIND v(dout0_0) AT=530.025n

* CHECK dout0_1 Vdout0_1ck105 = 1.0 time = 530
.meas tran vdout0_1ck105 FIND v(dout0_1) AT=530.025n

* CHECK dout0_2 Vdout0_2ck105 = 1.0 time = 530
.meas tran vdout0_2ck105 FIND v(dout0_2) AT=530.025n

* CHECK dout0_3 Vdout0_3ck105 = 0 time = 530
.meas tran vdout0_3ck105 FIND v(dout0_3) AT=530.025n

* CHECK dout0_4 Vdout0_4ck105 = 0 time = 530
.meas tran vdout0_4ck105 FIND v(dout0_4) AT=530.025n

* CHECK dout0_5 Vdout0_5ck105 = 0 time = 530
.meas tran vdout0_5ck105 FIND v(dout0_5) AT=530.025n

* CHECK dout0_6 Vdout0_6ck105 = 0 time = 530
.meas tran vdout0_6ck105 FIND v(dout0_6) AT=530.025n

* CHECK dout0_7 Vdout0_7ck105 = 0 time = 530
.meas tran vdout0_7ck105 FIND v(dout0_7) AT=530.025n

* CHECK dout0_0 Vdout0_0ck106 = 1.0 time = 535
.meas tran vdout0_0ck106 FIND v(dout0_0) AT=535.025n

* CHECK dout0_1 Vdout0_1ck106 = 1.0 time = 535
.meas tran vdout0_1ck106 FIND v(dout0_1) AT=535.025n

* CHECK dout0_2 Vdout0_2ck106 = 1.0 time = 535
.meas tran vdout0_2ck106 FIND v(dout0_2) AT=535.025n

* CHECK dout0_3 Vdout0_3ck106 = 0 time = 535
.meas tran vdout0_3ck106 FIND v(dout0_3) AT=535.025n

* CHECK dout0_4 Vdout0_4ck106 = 0 time = 535
.meas tran vdout0_4ck106 FIND v(dout0_4) AT=535.025n

* CHECK dout0_5 Vdout0_5ck106 = 0 time = 535
.meas tran vdout0_5ck106 FIND v(dout0_5) AT=535.025n

* CHECK dout0_6 Vdout0_6ck106 = 0 time = 535
.meas tran vdout0_6ck106 FIND v(dout0_6) AT=535.025n

* CHECK dout0_7 Vdout0_7ck106 = 0 time = 535
.meas tran vdout0_7ck106 FIND v(dout0_7) AT=535.025n

* CHECK dout0_0 Vdout0_0ck107 = 1.0 time = 540
.meas tran vdout0_0ck107 FIND v(dout0_0) AT=540.025n

* CHECK dout0_1 Vdout0_1ck107 = 1.0 time = 540
.meas tran vdout0_1ck107 FIND v(dout0_1) AT=540.025n

* CHECK dout0_2 Vdout0_2ck107 = 0 time = 540
.meas tran vdout0_2ck107 FIND v(dout0_2) AT=540.025n

* CHECK dout0_3 Vdout0_3ck107 = 1.0 time = 540
.meas tran vdout0_3ck107 FIND v(dout0_3) AT=540.025n

* CHECK dout0_4 Vdout0_4ck107 = 0 time = 540
.meas tran vdout0_4ck107 FIND v(dout0_4) AT=540.025n

* CHECK dout0_5 Vdout0_5ck107 = 1.0 time = 540
.meas tran vdout0_5ck107 FIND v(dout0_5) AT=540.025n

* CHECK dout0_6 Vdout0_6ck107 = 0 time = 540
.meas tran vdout0_6ck107 FIND v(dout0_6) AT=540.025n

* CHECK dout0_7 Vdout0_7ck107 = 0 time = 540
.meas tran vdout0_7ck107 FIND v(dout0_7) AT=540.025n

* CHECK dout0_0 Vdout0_0ck109 = 1.0 time = 550
.meas tran vdout0_0ck109 FIND v(dout0_0) AT=550.025n

* CHECK dout0_1 Vdout0_1ck109 = 0 time = 550
.meas tran vdout0_1ck109 FIND v(dout0_1) AT=550.025n

* CHECK dout0_2 Vdout0_2ck109 = 1.0 time = 550
.meas tran vdout0_2ck109 FIND v(dout0_2) AT=550.025n

* CHECK dout0_3 Vdout0_3ck109 = 0 time = 550
.meas tran vdout0_3ck109 FIND v(dout0_3) AT=550.025n

* CHECK dout0_4 Vdout0_4ck109 = 1.0 time = 550
.meas tran vdout0_4ck109 FIND v(dout0_4) AT=550.025n

* CHECK dout0_5 Vdout0_5ck109 = 0 time = 550
.meas tran vdout0_5ck109 FIND v(dout0_5) AT=550.025n

* CHECK dout0_6 Vdout0_6ck109 = 1.0 time = 550
.meas tran vdout0_6ck109 FIND v(dout0_6) AT=550.025n

* CHECK dout0_7 Vdout0_7ck109 = 0 time = 550
.meas tran vdout0_7ck109 FIND v(dout0_7) AT=550.025n

* CHECK dout0_0 Vdout0_0ck110 = 1.0 time = 555
.meas tran vdout0_0ck110 FIND v(dout0_0) AT=555.025n

* CHECK dout0_1 Vdout0_1ck110 = 1.0 time = 555
.meas tran vdout0_1ck110 FIND v(dout0_1) AT=555.025n

* CHECK dout0_2 Vdout0_2ck110 = 0 time = 555
.meas tran vdout0_2ck110 FIND v(dout0_2) AT=555.025n

* CHECK dout0_3 Vdout0_3ck110 = 0 time = 555
.meas tran vdout0_3ck110 FIND v(dout0_3) AT=555.025n

* CHECK dout0_4 Vdout0_4ck110 = 1.0 time = 555
.meas tran vdout0_4ck110 FIND v(dout0_4) AT=555.025n

* CHECK dout0_5 Vdout0_5ck110 = 0 time = 555
.meas tran vdout0_5ck110 FIND v(dout0_5) AT=555.025n

* CHECK dout0_6 Vdout0_6ck110 = 0 time = 555
.meas tran vdout0_6ck110 FIND v(dout0_6) AT=555.025n

* CHECK dout0_7 Vdout0_7ck110 = 0 time = 555
.meas tran vdout0_7ck110 FIND v(dout0_7) AT=555.025n

* CHECK dout0_0 Vdout0_0ck112 = 1.0 time = 565
.meas tran vdout0_0ck112 FIND v(dout0_0) AT=565.025n

* CHECK dout0_1 Vdout0_1ck112 = 1.0 time = 565
.meas tran vdout0_1ck112 FIND v(dout0_1) AT=565.025n

* CHECK dout0_2 Vdout0_2ck112 = 0 time = 565
.meas tran vdout0_2ck112 FIND v(dout0_2) AT=565.025n

* CHECK dout0_3 Vdout0_3ck112 = 1.0 time = 565
.meas tran vdout0_3ck112 FIND v(dout0_3) AT=565.025n

* CHECK dout0_4 Vdout0_4ck112 = 0 time = 565
.meas tran vdout0_4ck112 FIND v(dout0_4) AT=565.025n

* CHECK dout0_5 Vdout0_5ck112 = 1.0 time = 565
.meas tran vdout0_5ck112 FIND v(dout0_5) AT=565.025n

* CHECK dout0_6 Vdout0_6ck112 = 0 time = 565
.meas tran vdout0_6ck112 FIND v(dout0_6) AT=565.025n

* CHECK dout0_7 Vdout0_7ck112 = 0 time = 565
.meas tran vdout0_7ck112 FIND v(dout0_7) AT=565.025n

* CHECK dout0_0 Vdout0_0ck114 = 1.0 time = 575
.meas tran vdout0_0ck114 FIND v(dout0_0) AT=575.025n

* CHECK dout0_1 Vdout0_1ck114 = 1.0 time = 575
.meas tran vdout0_1ck114 FIND v(dout0_1) AT=575.025n

* CHECK dout0_2 Vdout0_2ck114 = 0 time = 575
.meas tran vdout0_2ck114 FIND v(dout0_2) AT=575.025n

* CHECK dout0_3 Vdout0_3ck114 = 1.0 time = 575
.meas tran vdout0_3ck114 FIND v(dout0_3) AT=575.025n

* CHECK dout0_4 Vdout0_4ck114 = 0 time = 575
.meas tran vdout0_4ck114 FIND v(dout0_4) AT=575.025n

* CHECK dout0_5 Vdout0_5ck114 = 1.0 time = 575
.meas tran vdout0_5ck114 FIND v(dout0_5) AT=575.025n

* CHECK dout0_6 Vdout0_6ck114 = 0 time = 575
.meas tran vdout0_6ck114 FIND v(dout0_6) AT=575.025n

* CHECK dout0_7 Vdout0_7ck114 = 1.0 time = 575
.meas tran vdout0_7ck114 FIND v(dout0_7) AT=575.025n

* CHECK dout0_0 Vdout0_0ck116 = 0 time = 585
.meas tran vdout0_0ck116 FIND v(dout0_0) AT=585.025n

* CHECK dout0_1 Vdout0_1ck116 = 0 time = 585
.meas tran vdout0_1ck116 FIND v(dout0_1) AT=585.025n

* CHECK dout0_2 Vdout0_2ck116 = 0 time = 585
.meas tran vdout0_2ck116 FIND v(dout0_2) AT=585.025n

* CHECK dout0_3 Vdout0_3ck116 = 0 time = 585
.meas tran vdout0_3ck116 FIND v(dout0_3) AT=585.025n

* CHECK dout0_4 Vdout0_4ck116 = 0 time = 585
.meas tran vdout0_4ck116 FIND v(dout0_4) AT=585.025n

* CHECK dout0_5 Vdout0_5ck116 = 0 time = 585
.meas tran vdout0_5ck116 FIND v(dout0_5) AT=585.025n

* CHECK dout0_6 Vdout0_6ck116 = 1.0 time = 585
.meas tran vdout0_6ck116 FIND v(dout0_6) AT=585.025n

* CHECK dout0_7 Vdout0_7ck116 = 1.0 time = 585
.meas tran vdout0_7ck116 FIND v(dout0_7) AT=585.025n

* CHECK dout0_0 Vdout0_0ck117 = 0 time = 590
.meas tran vdout0_0ck117 FIND v(dout0_0) AT=590.025n

* CHECK dout0_1 Vdout0_1ck117 = 1.0 time = 590
.meas tran vdout0_1ck117 FIND v(dout0_1) AT=590.025n

* CHECK dout0_2 Vdout0_2ck117 = 0 time = 590
.meas tran vdout0_2ck117 FIND v(dout0_2) AT=590.025n

* CHECK dout0_3 Vdout0_3ck117 = 1.0 time = 590
.meas tran vdout0_3ck117 FIND v(dout0_3) AT=590.025n

* CHECK dout0_4 Vdout0_4ck117 = 1.0 time = 590
.meas tran vdout0_4ck117 FIND v(dout0_4) AT=590.025n

* CHECK dout0_5 Vdout0_5ck117 = 1.0 time = 590
.meas tran vdout0_5ck117 FIND v(dout0_5) AT=590.025n

* CHECK dout0_6 Vdout0_6ck117 = 1.0 time = 590
.meas tran vdout0_6ck117 FIND v(dout0_6) AT=590.025n

* CHECK dout0_7 Vdout0_7ck117 = 1.0 time = 590
.meas tran vdout0_7ck117 FIND v(dout0_7) AT=590.025n

* CHECK dout0_0 Vdout0_0ck121 = 0 time = 610
.meas tran vdout0_0ck121 FIND v(dout0_0) AT=610.025n

* CHECK dout0_1 Vdout0_1ck121 = 0 time = 610
.meas tran vdout0_1ck121 FIND v(dout0_1) AT=610.025n

* CHECK dout0_2 Vdout0_2ck121 = 0 time = 610
.meas tran vdout0_2ck121 FIND v(dout0_2) AT=610.025n

* CHECK dout0_3 Vdout0_3ck121 = 1.0 time = 610
.meas tran vdout0_3ck121 FIND v(dout0_3) AT=610.025n

* CHECK dout0_4 Vdout0_4ck121 = 0 time = 610
.meas tran vdout0_4ck121 FIND v(dout0_4) AT=610.025n

* CHECK dout0_5 Vdout0_5ck121 = 0 time = 610
.meas tran vdout0_5ck121 FIND v(dout0_5) AT=610.025n

* CHECK dout0_6 Vdout0_6ck121 = 0 time = 610
.meas tran vdout0_6ck121 FIND v(dout0_6) AT=610.025n

* CHECK dout0_7 Vdout0_7ck121 = 1.0 time = 610
.meas tran vdout0_7ck121 FIND v(dout0_7) AT=610.025n

* CHECK dout0_0 Vdout0_0ck122 = 1.0 time = 615
.meas tran vdout0_0ck122 FIND v(dout0_0) AT=615.025n

* CHECK dout0_1 Vdout0_1ck122 = 0 time = 615
.meas tran vdout0_1ck122 FIND v(dout0_1) AT=615.025n

* CHECK dout0_2 Vdout0_2ck122 = 0 time = 615
.meas tran vdout0_2ck122 FIND v(dout0_2) AT=615.025n

* CHECK dout0_3 Vdout0_3ck122 = 0 time = 615
.meas tran vdout0_3ck122 FIND v(dout0_3) AT=615.025n

* CHECK dout0_4 Vdout0_4ck122 = 0 time = 615
.meas tran vdout0_4ck122 FIND v(dout0_4) AT=615.025n

* CHECK dout0_5 Vdout0_5ck122 = 1.0 time = 615
.meas tran vdout0_5ck122 FIND v(dout0_5) AT=615.025n

* CHECK dout0_6 Vdout0_6ck122 = 0 time = 615
.meas tran vdout0_6ck122 FIND v(dout0_6) AT=615.025n

* CHECK dout0_7 Vdout0_7ck122 = 0 time = 615
.meas tran vdout0_7ck122 FIND v(dout0_7) AT=615.025n

* CHECK dout0_0 Vdout0_0ck123 = 1.0 time = 620
.meas tran vdout0_0ck123 FIND v(dout0_0) AT=620.025n

* CHECK dout0_1 Vdout0_1ck123 = 1.0 time = 620
.meas tran vdout0_1ck123 FIND v(dout0_1) AT=620.025n

* CHECK dout0_2 Vdout0_2ck123 = 0 time = 620
.meas tran vdout0_2ck123 FIND v(dout0_2) AT=620.025n

* CHECK dout0_3 Vdout0_3ck123 = 0 time = 620
.meas tran vdout0_3ck123 FIND v(dout0_3) AT=620.025n

* CHECK dout0_4 Vdout0_4ck123 = 1.0 time = 620
.meas tran vdout0_4ck123 FIND v(dout0_4) AT=620.025n

* CHECK dout0_5 Vdout0_5ck123 = 0 time = 620
.meas tran vdout0_5ck123 FIND v(dout0_5) AT=620.025n

* CHECK dout0_6 Vdout0_6ck123 = 0 time = 620
.meas tran vdout0_6ck123 FIND v(dout0_6) AT=620.025n

* CHECK dout0_7 Vdout0_7ck123 = 0 time = 620
.meas tran vdout0_7ck123 FIND v(dout0_7) AT=620.025n

* CHECK dout0_0 Vdout0_0ck127 = 0 time = 640
.meas tran vdout0_0ck127 FIND v(dout0_0) AT=640.025n

* CHECK dout0_1 Vdout0_1ck127 = 1.0 time = 640
.meas tran vdout0_1ck127 FIND v(dout0_1) AT=640.025n

* CHECK dout0_2 Vdout0_2ck127 = 1.0 time = 640
.meas tran vdout0_2ck127 FIND v(dout0_2) AT=640.025n

* CHECK dout0_3 Vdout0_3ck127 = 0 time = 640
.meas tran vdout0_3ck127 FIND v(dout0_3) AT=640.025n

* CHECK dout0_4 Vdout0_4ck127 = 0 time = 640
.meas tran vdout0_4ck127 FIND v(dout0_4) AT=640.025n

* CHECK dout0_5 Vdout0_5ck127 = 0 time = 640
.meas tran vdout0_5ck127 FIND v(dout0_5) AT=640.025n

* CHECK dout0_6 Vdout0_6ck127 = 0 time = 640
.meas tran vdout0_6ck127 FIND v(dout0_6) AT=640.025n

* CHECK dout0_7 Vdout0_7ck127 = 0 time = 640
.meas tran vdout0_7ck127 FIND v(dout0_7) AT=640.025n

* CHECK dout0_0 Vdout0_0ck129 = 0 time = 650
.meas tran vdout0_0ck129 FIND v(dout0_0) AT=650.025n

* CHECK dout0_1 Vdout0_1ck129 = 0 time = 650
.meas tran vdout0_1ck129 FIND v(dout0_1) AT=650.025n

* CHECK dout0_2 Vdout0_2ck129 = 0 time = 650
.meas tran vdout0_2ck129 FIND v(dout0_2) AT=650.025n

* CHECK dout0_3 Vdout0_3ck129 = 0 time = 650
.meas tran vdout0_3ck129 FIND v(dout0_3) AT=650.025n

* CHECK dout0_4 Vdout0_4ck129 = 0 time = 650
.meas tran vdout0_4ck129 FIND v(dout0_4) AT=650.025n

* CHECK dout0_5 Vdout0_5ck129 = 0 time = 650
.meas tran vdout0_5ck129 FIND v(dout0_5) AT=650.025n

* CHECK dout0_6 Vdout0_6ck129 = 1.0 time = 650
.meas tran vdout0_6ck129 FIND v(dout0_6) AT=650.025n

* CHECK dout0_7 Vdout0_7ck129 = 1.0 time = 650
.meas tran vdout0_7ck129 FIND v(dout0_7) AT=650.025n

* CHECK dout0_0 Vdout0_0ck132 = 0 time = 665
.meas tran vdout0_0ck132 FIND v(dout0_0) AT=665.025n

* CHECK dout0_1 Vdout0_1ck132 = 0 time = 665
.meas tran vdout0_1ck132 FIND v(dout0_1) AT=665.025n

* CHECK dout0_2 Vdout0_2ck132 = 0 time = 665
.meas tran vdout0_2ck132 FIND v(dout0_2) AT=665.025n

* CHECK dout0_3 Vdout0_3ck132 = 0 time = 665
.meas tran vdout0_3ck132 FIND v(dout0_3) AT=665.025n

* CHECK dout0_4 Vdout0_4ck132 = 0 time = 665
.meas tran vdout0_4ck132 FIND v(dout0_4) AT=665.025n

* CHECK dout0_5 Vdout0_5ck132 = 0 time = 665
.meas tran vdout0_5ck132 FIND v(dout0_5) AT=665.025n

* CHECK dout0_6 Vdout0_6ck132 = 1.0 time = 665
.meas tran vdout0_6ck132 FIND v(dout0_6) AT=665.025n

* CHECK dout0_7 Vdout0_7ck132 = 1.0 time = 665
.meas tran vdout0_7ck132 FIND v(dout0_7) AT=665.025n

* CHECK dout0_0 Vdout0_0ck137 = 0 time = 690
.meas tran vdout0_0ck137 FIND v(dout0_0) AT=690.025n

* CHECK dout0_1 Vdout0_1ck137 = 1.0 time = 690
.meas tran vdout0_1ck137 FIND v(dout0_1) AT=690.025n

* CHECK dout0_2 Vdout0_2ck137 = 1.0 time = 690
.meas tran vdout0_2ck137 FIND v(dout0_2) AT=690.025n

* CHECK dout0_3 Vdout0_3ck137 = 0 time = 690
.meas tran vdout0_3ck137 FIND v(dout0_3) AT=690.025n

* CHECK dout0_4 Vdout0_4ck137 = 0 time = 690
.meas tran vdout0_4ck137 FIND v(dout0_4) AT=690.025n

* CHECK dout0_5 Vdout0_5ck137 = 1.0 time = 690
.meas tran vdout0_5ck137 FIND v(dout0_5) AT=690.025n

* CHECK dout0_6 Vdout0_6ck137 = 1.0 time = 690
.meas tran vdout0_6ck137 FIND v(dout0_6) AT=690.025n

* CHECK dout0_7 Vdout0_7ck137 = 0 time = 690
.meas tran vdout0_7ck137 FIND v(dout0_7) AT=690.025n

* CHECK dout0_0 Vdout0_0ck140 = 1.0 time = 705
.meas tran vdout0_0ck140 FIND v(dout0_0) AT=705.025n

* CHECK dout0_1 Vdout0_1ck140 = 1.0 time = 705
.meas tran vdout0_1ck140 FIND v(dout0_1) AT=705.025n

* CHECK dout0_2 Vdout0_2ck140 = 0 time = 705
.meas tran vdout0_2ck140 FIND v(dout0_2) AT=705.025n

* CHECK dout0_3 Vdout0_3ck140 = 0 time = 705
.meas tran vdout0_3ck140 FIND v(dout0_3) AT=705.025n

* CHECK dout0_4 Vdout0_4ck140 = 1.0 time = 705
.meas tran vdout0_4ck140 FIND v(dout0_4) AT=705.025n

* CHECK dout0_5 Vdout0_5ck140 = 0 time = 705
.meas tran vdout0_5ck140 FIND v(dout0_5) AT=705.025n

* CHECK dout0_6 Vdout0_6ck140 = 0 time = 705
.meas tran vdout0_6ck140 FIND v(dout0_6) AT=705.025n

* CHECK dout0_7 Vdout0_7ck140 = 0 time = 705
.meas tran vdout0_7ck140 FIND v(dout0_7) AT=705.025n

* CHECK dout0_0 Vdout0_0ck142 = 1.0 time = 715
.meas tran vdout0_0ck142 FIND v(dout0_0) AT=715.025n

* CHECK dout0_1 Vdout0_1ck142 = 1.0 time = 715
.meas tran vdout0_1ck142 FIND v(dout0_1) AT=715.025n

* CHECK dout0_2 Vdout0_2ck142 = 0 time = 715
.meas tran vdout0_2ck142 FIND v(dout0_2) AT=715.025n

* CHECK dout0_3 Vdout0_3ck142 = 0 time = 715
.meas tran vdout0_3ck142 FIND v(dout0_3) AT=715.025n

* CHECK dout0_4 Vdout0_4ck142 = 1.0 time = 715
.meas tran vdout0_4ck142 FIND v(dout0_4) AT=715.025n

* CHECK dout0_5 Vdout0_5ck142 = 1.0 time = 715
.meas tran vdout0_5ck142 FIND v(dout0_5) AT=715.025n

* CHECK dout0_6 Vdout0_6ck142 = 1.0 time = 715
.meas tran vdout0_6ck142 FIND v(dout0_6) AT=715.025n

* CHECK dout0_7 Vdout0_7ck142 = 1.0 time = 715
.meas tran vdout0_7ck142 FIND v(dout0_7) AT=715.025n

* CHECK dout0_0 Vdout0_0ck144 = 0 time = 725
.meas tran vdout0_0ck144 FIND v(dout0_0) AT=725.025n

* CHECK dout0_1 Vdout0_1ck144 = 1.0 time = 725
.meas tran vdout0_1ck144 FIND v(dout0_1) AT=725.025n

* CHECK dout0_2 Vdout0_2ck144 = 1.0 time = 725
.meas tran vdout0_2ck144 FIND v(dout0_2) AT=725.025n

* CHECK dout0_3 Vdout0_3ck144 = 0 time = 725
.meas tran vdout0_3ck144 FIND v(dout0_3) AT=725.025n

* CHECK dout0_4 Vdout0_4ck144 = 0 time = 725
.meas tran vdout0_4ck144 FIND v(dout0_4) AT=725.025n

* CHECK dout0_5 Vdout0_5ck144 = 1.0 time = 725
.meas tran vdout0_5ck144 FIND v(dout0_5) AT=725.025n

* CHECK dout0_6 Vdout0_6ck144 = 1.0 time = 725
.meas tran vdout0_6ck144 FIND v(dout0_6) AT=725.025n

* CHECK dout0_7 Vdout0_7ck144 = 0 time = 725
.meas tran vdout0_7ck144 FIND v(dout0_7) AT=725.025n

* CHECK dout0_0 Vdout0_0ck145 = 1.0 time = 730
.meas tran vdout0_0ck145 FIND v(dout0_0) AT=730.025n

* CHECK dout0_1 Vdout0_1ck145 = 1.0 time = 730
.meas tran vdout0_1ck145 FIND v(dout0_1) AT=730.025n

* CHECK dout0_2 Vdout0_2ck145 = 0 time = 730
.meas tran vdout0_2ck145 FIND v(dout0_2) AT=730.025n

* CHECK dout0_3 Vdout0_3ck145 = 1.0 time = 730
.meas tran vdout0_3ck145 FIND v(dout0_3) AT=730.025n

* CHECK dout0_4 Vdout0_4ck145 = 0 time = 730
.meas tran vdout0_4ck145 FIND v(dout0_4) AT=730.025n

* CHECK dout0_5 Vdout0_5ck145 = 1.0 time = 730
.meas tran vdout0_5ck145 FIND v(dout0_5) AT=730.025n

* CHECK dout0_6 Vdout0_6ck145 = 0 time = 730
.meas tran vdout0_6ck145 FIND v(dout0_6) AT=730.025n

* CHECK dout0_7 Vdout0_7ck145 = 0 time = 730
.meas tran vdout0_7ck145 FIND v(dout0_7) AT=730.025n

* CHECK dout0_0 Vdout0_0ck146 = 0 time = 735
.meas tran vdout0_0ck146 FIND v(dout0_0) AT=735.025n

* CHECK dout0_1 Vdout0_1ck146 = 1.0 time = 735
.meas tran vdout0_1ck146 FIND v(dout0_1) AT=735.025n

* CHECK dout0_2 Vdout0_2ck146 = 1.0 time = 735
.meas tran vdout0_2ck146 FIND v(dout0_2) AT=735.025n

* CHECK dout0_3 Vdout0_3ck146 = 0 time = 735
.meas tran vdout0_3ck146 FIND v(dout0_3) AT=735.025n

* CHECK dout0_4 Vdout0_4ck146 = 0 time = 735
.meas tran vdout0_4ck146 FIND v(dout0_4) AT=735.025n

* CHECK dout0_5 Vdout0_5ck146 = 1.0 time = 735
.meas tran vdout0_5ck146 FIND v(dout0_5) AT=735.025n

* CHECK dout0_6 Vdout0_6ck146 = 1.0 time = 735
.meas tran vdout0_6ck146 FIND v(dout0_6) AT=735.025n

* CHECK dout0_7 Vdout0_7ck146 = 0 time = 735
.meas tran vdout0_7ck146 FIND v(dout0_7) AT=735.025n

* CHECK dout0_0 Vdout0_0ck152 = 0 time = 765
.meas tran vdout0_0ck152 FIND v(dout0_0) AT=765.025n

* CHECK dout0_1 Vdout0_1ck152 = 1.0 time = 765
.meas tran vdout0_1ck152 FIND v(dout0_1) AT=765.025n

* CHECK dout0_2 Vdout0_2ck152 = 1.0 time = 765
.meas tran vdout0_2ck152 FIND v(dout0_2) AT=765.025n

* CHECK dout0_3 Vdout0_3ck152 = 1.0 time = 765
.meas tran vdout0_3ck152 FIND v(dout0_3) AT=765.025n

* CHECK dout0_4 Vdout0_4ck152 = 1.0 time = 765
.meas tran vdout0_4ck152 FIND v(dout0_4) AT=765.025n

* CHECK dout0_5 Vdout0_5ck152 = 1.0 time = 765
.meas tran vdout0_5ck152 FIND v(dout0_5) AT=765.025n

* CHECK dout0_6 Vdout0_6ck152 = 0 time = 765
.meas tran vdout0_6ck152 FIND v(dout0_6) AT=765.025n

* CHECK dout0_7 Vdout0_7ck152 = 0 time = 765
.meas tran vdout0_7ck152 FIND v(dout0_7) AT=765.025n

* CHECK dout0_0 Vdout0_0ck153 = 0 time = 770
.meas tran vdout0_0ck153 FIND v(dout0_0) AT=770.025n

* CHECK dout0_1 Vdout0_1ck153 = 0 time = 770
.meas tran vdout0_1ck153 FIND v(dout0_1) AT=770.025n

* CHECK dout0_2 Vdout0_2ck153 = 1.0 time = 770
.meas tran vdout0_2ck153 FIND v(dout0_2) AT=770.025n

* CHECK dout0_3 Vdout0_3ck153 = 1.0 time = 770
.meas tran vdout0_3ck153 FIND v(dout0_3) AT=770.025n

* CHECK dout0_4 Vdout0_4ck153 = 1.0 time = 770
.meas tran vdout0_4ck153 FIND v(dout0_4) AT=770.025n

* CHECK dout0_5 Vdout0_5ck153 = 0 time = 770
.meas tran vdout0_5ck153 FIND v(dout0_5) AT=770.025n

* CHECK dout0_6 Vdout0_6ck153 = 1.0 time = 770
.meas tran vdout0_6ck153 FIND v(dout0_6) AT=770.025n

* CHECK dout0_7 Vdout0_7ck153 = 0 time = 770
.meas tran vdout0_7ck153 FIND v(dout0_7) AT=770.025n

* CHECK dout0_0 Vdout0_0ck156 = 1.0 time = 785
.meas tran vdout0_0ck156 FIND v(dout0_0) AT=785.025n

* CHECK dout0_1 Vdout0_1ck156 = 0 time = 785
.meas tran vdout0_1ck156 FIND v(dout0_1) AT=785.025n

* CHECK dout0_2 Vdout0_2ck156 = 0 time = 785
.meas tran vdout0_2ck156 FIND v(dout0_2) AT=785.025n

* CHECK dout0_3 Vdout0_3ck156 = 0 time = 785
.meas tran vdout0_3ck156 FIND v(dout0_3) AT=785.025n

* CHECK dout0_4 Vdout0_4ck156 = 0 time = 785
.meas tran vdout0_4ck156 FIND v(dout0_4) AT=785.025n

* CHECK dout0_5 Vdout0_5ck156 = 1.0 time = 785
.meas tran vdout0_5ck156 FIND v(dout0_5) AT=785.025n

* CHECK dout0_6 Vdout0_6ck156 = 0 time = 785
.meas tran vdout0_6ck156 FIND v(dout0_6) AT=785.025n

* CHECK dout0_7 Vdout0_7ck156 = 1.0 time = 785
.meas tran vdout0_7ck156 FIND v(dout0_7) AT=785.025n

* CHECK dout0_0 Vdout0_0ck157 = 0 time = 790
.meas tran vdout0_0ck157 FIND v(dout0_0) AT=790.025n

* CHECK dout0_1 Vdout0_1ck157 = 1.0 time = 790
.meas tran vdout0_1ck157 FIND v(dout0_1) AT=790.025n

* CHECK dout0_2 Vdout0_2ck157 = 1.0 time = 790
.meas tran vdout0_2ck157 FIND v(dout0_2) AT=790.025n

* CHECK dout0_3 Vdout0_3ck157 = 0 time = 790
.meas tran vdout0_3ck157 FIND v(dout0_3) AT=790.025n

* CHECK dout0_4 Vdout0_4ck157 = 0 time = 790
.meas tran vdout0_4ck157 FIND v(dout0_4) AT=790.025n

* CHECK dout0_5 Vdout0_5ck157 = 1.0 time = 790
.meas tran vdout0_5ck157 FIND v(dout0_5) AT=790.025n

* CHECK dout0_6 Vdout0_6ck157 = 1.0 time = 790
.meas tran vdout0_6ck157 FIND v(dout0_6) AT=790.025n

* CHECK dout0_7 Vdout0_7ck157 = 0 time = 790
.meas tran vdout0_7ck157 FIND v(dout0_7) AT=790.025n

* CHECK dout0_0 Vdout0_0ck161 = 1.0 time = 810
.meas tran vdout0_0ck161 FIND v(dout0_0) AT=810.025n

* CHECK dout0_1 Vdout0_1ck161 = 0 time = 810
.meas tran vdout0_1ck161 FIND v(dout0_1) AT=810.025n

* CHECK dout0_2 Vdout0_2ck161 = 0 time = 810
.meas tran vdout0_2ck161 FIND v(dout0_2) AT=810.025n

* CHECK dout0_3 Vdout0_3ck161 = 0 time = 810
.meas tran vdout0_3ck161 FIND v(dout0_3) AT=810.025n

* CHECK dout0_4 Vdout0_4ck161 = 0 time = 810
.meas tran vdout0_4ck161 FIND v(dout0_4) AT=810.025n

* CHECK dout0_5 Vdout0_5ck161 = 1.0 time = 810
.meas tran vdout0_5ck161 FIND v(dout0_5) AT=810.025n

* CHECK dout0_6 Vdout0_6ck161 = 0 time = 810
.meas tran vdout0_6ck161 FIND v(dout0_6) AT=810.025n

* CHECK dout0_7 Vdout0_7ck161 = 0 time = 810
.meas tran vdout0_7ck161 FIND v(dout0_7) AT=810.025n

* CHECK dout0_0 Vdout0_0ck162 = 1.0 time = 815
.meas tran vdout0_0ck162 FIND v(dout0_0) AT=815.025n

* CHECK dout0_1 Vdout0_1ck162 = 0 time = 815
.meas tran vdout0_1ck162 FIND v(dout0_1) AT=815.025n

* CHECK dout0_2 Vdout0_2ck162 = 0 time = 815
.meas tran vdout0_2ck162 FIND v(dout0_2) AT=815.025n

* CHECK dout0_3 Vdout0_3ck162 = 0 time = 815
.meas tran vdout0_3ck162 FIND v(dout0_3) AT=815.025n

* CHECK dout0_4 Vdout0_4ck162 = 0 time = 815
.meas tran vdout0_4ck162 FIND v(dout0_4) AT=815.025n

* CHECK dout0_5 Vdout0_5ck162 = 1.0 time = 815
.meas tran vdout0_5ck162 FIND v(dout0_5) AT=815.025n

* CHECK dout0_6 Vdout0_6ck162 = 0 time = 815
.meas tran vdout0_6ck162 FIND v(dout0_6) AT=815.025n

* CHECK dout0_7 Vdout0_7ck162 = 0 time = 815
.meas tran vdout0_7ck162 FIND v(dout0_7) AT=815.025n

* CHECK dout0_0 Vdout0_0ck163 = 1.0 time = 820
.meas tran vdout0_0ck163 FIND v(dout0_0) AT=820.025n

* CHECK dout0_1 Vdout0_1ck163 = 0 time = 820
.meas tran vdout0_1ck163 FIND v(dout0_1) AT=820.025n

* CHECK dout0_2 Vdout0_2ck163 = 1.0 time = 820
.meas tran vdout0_2ck163 FIND v(dout0_2) AT=820.025n

* CHECK dout0_3 Vdout0_3ck163 = 0 time = 820
.meas tran vdout0_3ck163 FIND v(dout0_3) AT=820.025n

* CHECK dout0_4 Vdout0_4ck163 = 1.0 time = 820
.meas tran vdout0_4ck163 FIND v(dout0_4) AT=820.025n

* CHECK dout0_5 Vdout0_5ck163 = 1.0 time = 820
.meas tran vdout0_5ck163 FIND v(dout0_5) AT=820.025n

* CHECK dout0_6 Vdout0_6ck163 = 1.0 time = 820
.meas tran vdout0_6ck163 FIND v(dout0_6) AT=820.025n

* CHECK dout0_7 Vdout0_7ck163 = 1.0 time = 820
.meas tran vdout0_7ck163 FIND v(dout0_7) AT=820.025n

* CHECK dout0_0 Vdout0_0ck167 = 0 time = 840
.meas tran vdout0_0ck167 FIND v(dout0_0) AT=840.025n

* CHECK dout0_1 Vdout0_1ck167 = 0 time = 840
.meas tran vdout0_1ck167 FIND v(dout0_1) AT=840.025n

* CHECK dout0_2 Vdout0_2ck167 = 1.0 time = 840
.meas tran vdout0_2ck167 FIND v(dout0_2) AT=840.025n

* CHECK dout0_3 Vdout0_3ck167 = 1.0 time = 840
.meas tran vdout0_3ck167 FIND v(dout0_3) AT=840.025n

* CHECK dout0_4 Vdout0_4ck167 = 1.0 time = 840
.meas tran vdout0_4ck167 FIND v(dout0_4) AT=840.025n

* CHECK dout0_5 Vdout0_5ck167 = 1.0 time = 840
.meas tran vdout0_5ck167 FIND v(dout0_5) AT=840.025n

* CHECK dout0_6 Vdout0_6ck167 = 1.0 time = 840
.meas tran vdout0_6ck167 FIND v(dout0_6) AT=840.025n

* CHECK dout0_7 Vdout0_7ck167 = 0 time = 840
.meas tran vdout0_7ck167 FIND v(dout0_7) AT=840.025n

* CHECK dout0_0 Vdout0_0ck168 = 0 time = 845
.meas tran vdout0_0ck168 FIND v(dout0_0) AT=845.025n

* CHECK dout0_1 Vdout0_1ck168 = 0 time = 845
.meas tran vdout0_1ck168 FIND v(dout0_1) AT=845.025n

* CHECK dout0_2 Vdout0_2ck168 = 0 time = 845
.meas tran vdout0_2ck168 FIND v(dout0_2) AT=845.025n

* CHECK dout0_3 Vdout0_3ck168 = 0 time = 845
.meas tran vdout0_3ck168 FIND v(dout0_3) AT=845.025n

* CHECK dout0_4 Vdout0_4ck168 = 0 time = 845
.meas tran vdout0_4ck168 FIND v(dout0_4) AT=845.025n

* CHECK dout0_5 Vdout0_5ck168 = 0 time = 845
.meas tran vdout0_5ck168 FIND v(dout0_5) AT=845.025n

* CHECK dout0_6 Vdout0_6ck168 = 1.0 time = 845
.meas tran vdout0_6ck168 FIND v(dout0_6) AT=845.025n

* CHECK dout0_7 Vdout0_7ck168 = 1.0 time = 845
.meas tran vdout0_7ck168 FIND v(dout0_7) AT=845.025n

* CHECK dout0_0 Vdout0_0ck169 = 0 time = 850
.meas tran vdout0_0ck169 FIND v(dout0_0) AT=850.025n

* CHECK dout0_1 Vdout0_1ck169 = 0 time = 850
.meas tran vdout0_1ck169 FIND v(dout0_1) AT=850.025n

* CHECK dout0_2 Vdout0_2ck169 = 0 time = 850
.meas tran vdout0_2ck169 FIND v(dout0_2) AT=850.025n

* CHECK dout0_3 Vdout0_3ck169 = 1.0 time = 850
.meas tran vdout0_3ck169 FIND v(dout0_3) AT=850.025n

* CHECK dout0_4 Vdout0_4ck169 = 0 time = 850
.meas tran vdout0_4ck169 FIND v(dout0_4) AT=850.025n

* CHECK dout0_5 Vdout0_5ck169 = 0 time = 850
.meas tran vdout0_5ck169 FIND v(dout0_5) AT=850.025n

* CHECK dout0_6 Vdout0_6ck169 = 1.0 time = 850
.meas tran vdout0_6ck169 FIND v(dout0_6) AT=850.025n

* CHECK dout0_7 Vdout0_7ck169 = 0 time = 850
.meas tran vdout0_7ck169 FIND v(dout0_7) AT=850.025n

* CHECK dout0_0 Vdout0_0ck172 = 0 time = 865
.meas tran vdout0_0ck172 FIND v(dout0_0) AT=865.025n

* CHECK dout0_1 Vdout0_1ck172 = 1.0 time = 865
.meas tran vdout0_1ck172 FIND v(dout0_1) AT=865.025n

* CHECK dout0_2 Vdout0_2ck172 = 0 time = 865
.meas tran vdout0_2ck172 FIND v(dout0_2) AT=865.025n

* CHECK dout0_3 Vdout0_3ck172 = 1.0 time = 865
.meas tran vdout0_3ck172 FIND v(dout0_3) AT=865.025n

* CHECK dout0_4 Vdout0_4ck172 = 1.0 time = 865
.meas tran vdout0_4ck172 FIND v(dout0_4) AT=865.025n

* CHECK dout0_5 Vdout0_5ck172 = 1.0 time = 865
.meas tran vdout0_5ck172 FIND v(dout0_5) AT=865.025n

* CHECK dout0_6 Vdout0_6ck172 = 1.0 time = 865
.meas tran vdout0_6ck172 FIND v(dout0_6) AT=865.025n

* CHECK dout0_7 Vdout0_7ck172 = 1.0 time = 865
.meas tran vdout0_7ck172 FIND v(dout0_7) AT=865.025n

* CHECK dout0_0 Vdout0_0ck173 = 0 time = 870
.meas tran vdout0_0ck173 FIND v(dout0_0) AT=870.025n

* CHECK dout0_1 Vdout0_1ck173 = 0 time = 870
.meas tran vdout0_1ck173 FIND v(dout0_1) AT=870.025n

* CHECK dout0_2 Vdout0_2ck173 = 1.0 time = 870
.meas tran vdout0_2ck173 FIND v(dout0_2) AT=870.025n

* CHECK dout0_3 Vdout0_3ck173 = 0 time = 870
.meas tran vdout0_3ck173 FIND v(dout0_3) AT=870.025n

* CHECK dout0_4 Vdout0_4ck173 = 1.0 time = 870
.meas tran vdout0_4ck173 FIND v(dout0_4) AT=870.025n

* CHECK dout0_5 Vdout0_5ck173 = 1.0 time = 870
.meas tran vdout0_5ck173 FIND v(dout0_5) AT=870.025n

* CHECK dout0_6 Vdout0_6ck173 = 1.0 time = 870
.meas tran vdout0_6ck173 FIND v(dout0_6) AT=870.025n

* CHECK dout0_7 Vdout0_7ck173 = 0 time = 870
.meas tran vdout0_7ck173 FIND v(dout0_7) AT=870.025n

* CHECK dout0_0 Vdout0_0ck174 = 0 time = 875
.meas tran vdout0_0ck174 FIND v(dout0_0) AT=875.025n

* CHECK dout0_1 Vdout0_1ck174 = 0 time = 875
.meas tran vdout0_1ck174 FIND v(dout0_1) AT=875.025n

* CHECK dout0_2 Vdout0_2ck174 = 1.0 time = 875
.meas tran vdout0_2ck174 FIND v(dout0_2) AT=875.025n

* CHECK dout0_3 Vdout0_3ck174 = 0 time = 875
.meas tran vdout0_3ck174 FIND v(dout0_3) AT=875.025n

* CHECK dout0_4 Vdout0_4ck174 = 1.0 time = 875
.meas tran vdout0_4ck174 FIND v(dout0_4) AT=875.025n

* CHECK dout0_5 Vdout0_5ck174 = 1.0 time = 875
.meas tran vdout0_5ck174 FIND v(dout0_5) AT=875.025n

* CHECK dout0_6 Vdout0_6ck174 = 1.0 time = 875
.meas tran vdout0_6ck174 FIND v(dout0_6) AT=875.025n

* CHECK dout0_7 Vdout0_7ck174 = 0 time = 875
.meas tran vdout0_7ck174 FIND v(dout0_7) AT=875.025n

* CHECK dout0_0 Vdout0_0ck175 = 0 time = 880
.meas tran vdout0_0ck175 FIND v(dout0_0) AT=880.025n

* CHECK dout0_1 Vdout0_1ck175 = 0 time = 880
.meas tran vdout0_1ck175 FIND v(dout0_1) AT=880.025n

* CHECK dout0_2 Vdout0_2ck175 = 1.0 time = 880
.meas tran vdout0_2ck175 FIND v(dout0_2) AT=880.025n

* CHECK dout0_3 Vdout0_3ck175 = 1.0 time = 880
.meas tran vdout0_3ck175 FIND v(dout0_3) AT=880.025n

* CHECK dout0_4 Vdout0_4ck175 = 1.0 time = 880
.meas tran vdout0_4ck175 FIND v(dout0_4) AT=880.025n

* CHECK dout0_5 Vdout0_5ck175 = 0 time = 880
.meas tran vdout0_5ck175 FIND v(dout0_5) AT=880.025n

* CHECK dout0_6 Vdout0_6ck175 = 1.0 time = 880
.meas tran vdout0_6ck175 FIND v(dout0_6) AT=880.025n

* CHECK dout0_7 Vdout0_7ck175 = 0 time = 880
.meas tran vdout0_7ck175 FIND v(dout0_7) AT=880.025n

* CHECK dout0_0 Vdout0_0ck176 = 0 time = 885
.meas tran vdout0_0ck176 FIND v(dout0_0) AT=885.025n

* CHECK dout0_1 Vdout0_1ck176 = 0 time = 885
.meas tran vdout0_1ck176 FIND v(dout0_1) AT=885.025n

* CHECK dout0_2 Vdout0_2ck176 = 1.0 time = 885
.meas tran vdout0_2ck176 FIND v(dout0_2) AT=885.025n

* CHECK dout0_3 Vdout0_3ck176 = 0 time = 885
.meas tran vdout0_3ck176 FIND v(dout0_3) AT=885.025n

* CHECK dout0_4 Vdout0_4ck176 = 1.0 time = 885
.meas tran vdout0_4ck176 FIND v(dout0_4) AT=885.025n

* CHECK dout0_5 Vdout0_5ck176 = 1.0 time = 885
.meas tran vdout0_5ck176 FIND v(dout0_5) AT=885.025n

* CHECK dout0_6 Vdout0_6ck176 = 1.0 time = 885
.meas tran vdout0_6ck176 FIND v(dout0_6) AT=885.025n

* CHECK dout0_7 Vdout0_7ck176 = 0 time = 885
.meas tran vdout0_7ck176 FIND v(dout0_7) AT=885.025n

* CHECK dout0_0 Vdout0_0ck180 = 0 time = 905
.meas tran vdout0_0ck180 FIND v(dout0_0) AT=905.025n

* CHECK dout0_1 Vdout0_1ck180 = 0 time = 905
.meas tran vdout0_1ck180 FIND v(dout0_1) AT=905.025n

* CHECK dout0_2 Vdout0_2ck180 = 1.0 time = 905
.meas tran vdout0_2ck180 FIND v(dout0_2) AT=905.025n

* CHECK dout0_3 Vdout0_3ck180 = 1.0 time = 905
.meas tran vdout0_3ck180 FIND v(dout0_3) AT=905.025n

* CHECK dout0_4 Vdout0_4ck180 = 1.0 time = 905
.meas tran vdout0_4ck180 FIND v(dout0_4) AT=905.025n

* CHECK dout0_5 Vdout0_5ck180 = 1.0 time = 905
.meas tran vdout0_5ck180 FIND v(dout0_5) AT=905.025n

* CHECK dout0_6 Vdout0_6ck180 = 0 time = 905
.meas tran vdout0_6ck180 FIND v(dout0_6) AT=905.025n

* CHECK dout0_7 Vdout0_7ck180 = 0 time = 905
.meas tran vdout0_7ck180 FIND v(dout0_7) AT=905.025n

* CHECK dout0_0 Vdout0_0ck182 = 0 time = 915
.meas tran vdout0_0ck182 FIND v(dout0_0) AT=915.025n

* CHECK dout0_1 Vdout0_1ck182 = 1.0 time = 915
.meas tran vdout0_1ck182 FIND v(dout0_1) AT=915.025n

* CHECK dout0_2 Vdout0_2ck182 = 1.0 time = 915
.meas tran vdout0_2ck182 FIND v(dout0_2) AT=915.025n

* CHECK dout0_3 Vdout0_3ck182 = 1.0 time = 915
.meas tran vdout0_3ck182 FIND v(dout0_3) AT=915.025n

* CHECK dout0_4 Vdout0_4ck182 = 1.0 time = 915
.meas tran vdout0_4ck182 FIND v(dout0_4) AT=915.025n

* CHECK dout0_5 Vdout0_5ck182 = 0 time = 915
.meas tran vdout0_5ck182 FIND v(dout0_5) AT=915.025n

* CHECK dout0_6 Vdout0_6ck182 = 0 time = 915
.meas tran vdout0_6ck182 FIND v(dout0_6) AT=915.025n

* CHECK dout0_7 Vdout0_7ck182 = 1.0 time = 915
.meas tran vdout0_7ck182 FIND v(dout0_7) AT=915.025n

* CHECK dout0_0 Vdout0_0ck185 = 1.0 time = 930
.meas tran vdout0_0ck185 FIND v(dout0_0) AT=930.025n

* CHECK dout0_1 Vdout0_1ck185 = 0 time = 930
.meas tran vdout0_1ck185 FIND v(dout0_1) AT=930.025n

* CHECK dout0_2 Vdout0_2ck185 = 0 time = 930
.meas tran vdout0_2ck185 FIND v(dout0_2) AT=930.025n

* CHECK dout0_3 Vdout0_3ck185 = 1.0 time = 930
.meas tran vdout0_3ck185 FIND v(dout0_3) AT=930.025n

* CHECK dout0_4 Vdout0_4ck185 = 0 time = 930
.meas tran vdout0_4ck185 FIND v(dout0_4) AT=930.025n

* CHECK dout0_5 Vdout0_5ck185 = 0 time = 930
.meas tran vdout0_5ck185 FIND v(dout0_5) AT=930.025n

* CHECK dout0_6 Vdout0_6ck185 = 0 time = 930
.meas tran vdout0_6ck185 FIND v(dout0_6) AT=930.025n

* CHECK dout0_7 Vdout0_7ck185 = 1.0 time = 930
.meas tran vdout0_7ck185 FIND v(dout0_7) AT=930.025n

* CHECK dout0_0 Vdout0_0ck187 = 1.0 time = 940
.meas tran vdout0_0ck187 FIND v(dout0_0) AT=940.025n

* CHECK dout0_1 Vdout0_1ck187 = 1.0 time = 940
.meas tran vdout0_1ck187 FIND v(dout0_1) AT=940.025n

* CHECK dout0_2 Vdout0_2ck187 = 1.0 time = 940
.meas tran vdout0_2ck187 FIND v(dout0_2) AT=940.025n

* CHECK dout0_3 Vdout0_3ck187 = 1.0 time = 940
.meas tran vdout0_3ck187 FIND v(dout0_3) AT=940.025n

* CHECK dout0_4 Vdout0_4ck187 = 0 time = 940
.meas tran vdout0_4ck187 FIND v(dout0_4) AT=940.025n

* CHECK dout0_5 Vdout0_5ck187 = 1.0 time = 940
.meas tran vdout0_5ck187 FIND v(dout0_5) AT=940.025n

* CHECK dout0_6 Vdout0_6ck187 = 0 time = 940
.meas tran vdout0_6ck187 FIND v(dout0_6) AT=940.025n

* CHECK dout0_7 Vdout0_7ck187 = 1.0 time = 940
.meas tran vdout0_7ck187 FIND v(dout0_7) AT=940.025n

* CHECK dout0_0 Vdout0_0ck189 = 1.0 time = 950
.meas tran vdout0_0ck189 FIND v(dout0_0) AT=950.025n

* CHECK dout0_1 Vdout0_1ck189 = 1.0 time = 950
.meas tran vdout0_1ck189 FIND v(dout0_1) AT=950.025n

* CHECK dout0_2 Vdout0_2ck189 = 0 time = 950
.meas tran vdout0_2ck189 FIND v(dout0_2) AT=950.025n

* CHECK dout0_3 Vdout0_3ck189 = 0 time = 950
.meas tran vdout0_3ck189 FIND v(dout0_3) AT=950.025n

* CHECK dout0_4 Vdout0_4ck189 = 1.0 time = 950
.meas tran vdout0_4ck189 FIND v(dout0_4) AT=950.025n

* CHECK dout0_5 Vdout0_5ck189 = 1.0 time = 950
.meas tran vdout0_5ck189 FIND v(dout0_5) AT=950.025n

* CHECK dout0_6 Vdout0_6ck189 = 1.0 time = 950
.meas tran vdout0_6ck189 FIND v(dout0_6) AT=950.025n

* CHECK dout0_7 Vdout0_7ck189 = 1.0 time = 950
.meas tran vdout0_7ck189 FIND v(dout0_7) AT=950.025n

* CHECK dout0_0 Vdout0_0ck191 = 1.0 time = 960
.meas tran vdout0_0ck191 FIND v(dout0_0) AT=960.025n

* CHECK dout0_1 Vdout0_1ck191 = 0 time = 960
.meas tran vdout0_1ck191 FIND v(dout0_1) AT=960.025n

* CHECK dout0_2 Vdout0_2ck191 = 0 time = 960
.meas tran vdout0_2ck191 FIND v(dout0_2) AT=960.025n

* CHECK dout0_3 Vdout0_3ck191 = 0 time = 960
.meas tran vdout0_3ck191 FIND v(dout0_3) AT=960.025n

* CHECK dout0_4 Vdout0_4ck191 = 0 time = 960
.meas tran vdout0_4ck191 FIND v(dout0_4) AT=960.025n

* CHECK dout0_5 Vdout0_5ck191 = 1.0 time = 960
.meas tran vdout0_5ck191 FIND v(dout0_5) AT=960.025n

* CHECK dout0_6 Vdout0_6ck191 = 0 time = 960
.meas tran vdout0_6ck191 FIND v(dout0_6) AT=960.025n

* CHECK dout0_7 Vdout0_7ck191 = 0 time = 960
.meas tran vdout0_7ck191 FIND v(dout0_7) AT=960.025n

* CHECK dout0_0 Vdout0_0ck194 = 1.0 time = 975
.meas tran vdout0_0ck194 FIND v(dout0_0) AT=975.025n

* CHECK dout0_1 Vdout0_1ck194 = 0 time = 975
.meas tran vdout0_1ck194 FIND v(dout0_1) AT=975.025n

* CHECK dout0_2 Vdout0_2ck194 = 0 time = 975
.meas tran vdout0_2ck194 FIND v(dout0_2) AT=975.025n

* CHECK dout0_3 Vdout0_3ck194 = 1.0 time = 975
.meas tran vdout0_3ck194 FIND v(dout0_3) AT=975.025n

* CHECK dout0_4 Vdout0_4ck194 = 0 time = 975
.meas tran vdout0_4ck194 FIND v(dout0_4) AT=975.025n

* CHECK dout0_5 Vdout0_5ck194 = 0 time = 975
.meas tran vdout0_5ck194 FIND v(dout0_5) AT=975.025n

* CHECK dout0_6 Vdout0_6ck194 = 0 time = 975
.meas tran vdout0_6ck194 FIND v(dout0_6) AT=975.025n

* CHECK dout0_7 Vdout0_7ck194 = 1.0 time = 975
.meas tran vdout0_7ck194 FIND v(dout0_7) AT=975.025n

* CHECK dout0_0 Vdout0_0ck195 = 0 time = 980
.meas tran vdout0_0ck195 FIND v(dout0_0) AT=980.025n

* CHECK dout0_1 Vdout0_1ck195 = 0 time = 980
.meas tran vdout0_1ck195 FIND v(dout0_1) AT=980.025n

* CHECK dout0_2 Vdout0_2ck195 = 1.0 time = 980
.meas tran vdout0_2ck195 FIND v(dout0_2) AT=980.025n

* CHECK dout0_3 Vdout0_3ck195 = 0 time = 980
.meas tran vdout0_3ck195 FIND v(dout0_3) AT=980.025n

* CHECK dout0_4 Vdout0_4ck195 = 1.0 time = 980
.meas tran vdout0_4ck195 FIND v(dout0_4) AT=980.025n

* CHECK dout0_5 Vdout0_5ck195 = 1.0 time = 980
.meas tran vdout0_5ck195 FIND v(dout0_5) AT=980.025n

* CHECK dout0_6 Vdout0_6ck195 = 1.0 time = 980
.meas tran vdout0_6ck195 FIND v(dout0_6) AT=980.025n

* CHECK dout0_7 Vdout0_7ck195 = 0 time = 980
.meas tran vdout0_7ck195 FIND v(dout0_7) AT=980.025n

* CHECK dout0_0 Vdout0_0ck196 = 0 time = 985
.meas tran vdout0_0ck196 FIND v(dout0_0) AT=985.025n

* CHECK dout0_1 Vdout0_1ck196 = 0 time = 985
.meas tran vdout0_1ck196 FIND v(dout0_1) AT=985.025n

* CHECK dout0_2 Vdout0_2ck196 = 1.0 time = 985
.meas tran vdout0_2ck196 FIND v(dout0_2) AT=985.025n

* CHECK dout0_3 Vdout0_3ck196 = 1.0 time = 985
.meas tran vdout0_3ck196 FIND v(dout0_3) AT=985.025n

* CHECK dout0_4 Vdout0_4ck196 = 1.0 time = 985
.meas tran vdout0_4ck196 FIND v(dout0_4) AT=985.025n

* CHECK dout0_5 Vdout0_5ck196 = 0 time = 985
.meas tran vdout0_5ck196 FIND v(dout0_5) AT=985.025n

* CHECK dout0_6 Vdout0_6ck196 = 1.0 time = 985
.meas tran vdout0_6ck196 FIND v(dout0_6) AT=985.025n

* CHECK dout0_7 Vdout0_7ck196 = 0 time = 985
.meas tran vdout0_7ck196 FIND v(dout0_7) AT=985.025n

* CHECK dout0_0 Vdout0_0ck197 = 0 time = 990
.meas tran vdout0_0ck197 FIND v(dout0_0) AT=990.025n

* CHECK dout0_1 Vdout0_1ck197 = 0 time = 990
.meas tran vdout0_1ck197 FIND v(dout0_1) AT=990.025n

* CHECK dout0_2 Vdout0_2ck197 = 1.0 time = 990
.meas tran vdout0_2ck197 FIND v(dout0_2) AT=990.025n

* CHECK dout0_3 Vdout0_3ck197 = 1.0 time = 990
.meas tran vdout0_3ck197 FIND v(dout0_3) AT=990.025n

* CHECK dout0_4 Vdout0_4ck197 = 1.0 time = 990
.meas tran vdout0_4ck197 FIND v(dout0_4) AT=990.025n

* CHECK dout0_5 Vdout0_5ck197 = 0 time = 990
.meas tran vdout0_5ck197 FIND v(dout0_5) AT=990.025n

* CHECK dout0_6 Vdout0_6ck197 = 1.0 time = 990
.meas tran vdout0_6ck197 FIND v(dout0_6) AT=990.025n

* CHECK dout0_7 Vdout0_7ck197 = 0 time = 990
.meas tran vdout0_7ck197 FIND v(dout0_7) AT=990.025n

* CHECK dout0_0 Vdout0_0ck199 = 1.0 time = 1000
.meas tran vdout0_0ck199 FIND v(dout0_0) AT=1000.025n

* CHECK dout0_1 Vdout0_1ck199 = 1.0 time = 1000
.meas tran vdout0_1ck199 FIND v(dout0_1) AT=1000.025n

* CHECK dout0_2 Vdout0_2ck199 = 0 time = 1000
.meas tran vdout0_2ck199 FIND v(dout0_2) AT=1000.025n

* CHECK dout0_3 Vdout0_3ck199 = 0 time = 1000
.meas tran vdout0_3ck199 FIND v(dout0_3) AT=1000.025n

* CHECK dout0_4 Vdout0_4ck199 = 1.0 time = 1000
.meas tran vdout0_4ck199 FIND v(dout0_4) AT=1000.025n

* CHECK dout0_5 Vdout0_5ck199 = 1.0 time = 1000
.meas tran vdout0_5ck199 FIND v(dout0_5) AT=1000.025n

* CHECK dout0_6 Vdout0_6ck199 = 1.0 time = 1000
.meas tran vdout0_6ck199 FIND v(dout0_6) AT=1000.025n

* CHECK dout0_7 Vdout0_7ck199 = 1.0 time = 1000
.meas tran vdout0_7ck199 FIND v(dout0_7) AT=1000.025n

* CHECK dout0_0 Vdout0_0ck201 = 1.0 time = 1010
.meas tran vdout0_0ck201 FIND v(dout0_0) AT=1010.025n

* CHECK dout0_1 Vdout0_1ck201 = 1.0 time = 1010
.meas tran vdout0_1ck201 FIND v(dout0_1) AT=1010.025n

* CHECK dout0_2 Vdout0_2ck201 = 1.0 time = 1010
.meas tran vdout0_2ck201 FIND v(dout0_2) AT=1010.025n

* CHECK dout0_3 Vdout0_3ck201 = 1.0 time = 1010
.meas tran vdout0_3ck201 FIND v(dout0_3) AT=1010.025n

* CHECK dout0_4 Vdout0_4ck201 = 0 time = 1010
.meas tran vdout0_4ck201 FIND v(dout0_4) AT=1010.025n

* CHECK dout0_5 Vdout0_5ck201 = 1.0 time = 1010
.meas tran vdout0_5ck201 FIND v(dout0_5) AT=1010.025n

* CHECK dout0_6 Vdout0_6ck201 = 0 time = 1010
.meas tran vdout0_6ck201 FIND v(dout0_6) AT=1010.025n

* CHECK dout0_7 Vdout0_7ck201 = 1.0 time = 1010
.meas tran vdout0_7ck201 FIND v(dout0_7) AT=1010.025n

* probe is used for hspice/xa, while plot is used in ngspice
*.probe V(*)
*.plot V(*)
.end
